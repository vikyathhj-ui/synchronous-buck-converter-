* Window-ADC reference (generated by scripts/char_adcref.py)
* adc_string: 520 x high_po_1p41 (L = 3 um); node k = k x 2.5 mV for a 1.300 V top.
.subckt adc_string top vss
XR0 n1 vss vss sky130_fd_pr__res_high_po_1p41 l=3 mult=1
XR1 n2 n1 vss sky130_fd_pr__res_high_po_1p41 l=3 mult=1
XR2 n3 n2 vss sky130_fd_pr__res_high_po_1p41 l=3 mult=1
XR3 n4 n3 vss sky130_fd_pr__res_high_po_1p41 l=3 mult=1
XR4 n5 n4 vss sky130_fd_pr__res_high_po_1p41 l=3 mult=1
XR5 n6 n5 vss sky130_fd_pr__res_high_po_1p41 l=3 mult=1
XR6 n7 n6 vss sky130_fd_pr__res_high_po_1p41 l=3 mult=1
XR7 n8 n7 vss sky130_fd_pr__res_high_po_1p41 l=3 mult=1
XR8 n9 n8 vss sky130_fd_pr__res_high_po_1p41 l=3 mult=1
XR9 n10 n9 vss sky130_fd_pr__res_high_po_1p41 l=3 mult=1
XR10 n11 n10 vss sky130_fd_pr__res_high_po_1p41 l=3 mult=1
XR11 n12 n11 vss sky130_fd_pr__res_high_po_1p41 l=3 mult=1
XR12 n13 n12 vss sky130_fd_pr__res_high_po_1p41 l=3 mult=1
XR13 n14 n13 vss sky130_fd_pr__res_high_po_1p41 l=3 mult=1
XR14 n15 n14 vss sky130_fd_pr__res_high_po_1p41 l=3 mult=1
XR15 n16 n15 vss sky130_fd_pr__res_high_po_1p41 l=3 mult=1
XR16 n17 n16 vss sky130_fd_pr__res_high_po_1p41 l=3 mult=1
XR17 n18 n17 vss sky130_fd_pr__res_high_po_1p41 l=3 mult=1
XR18 n19 n18 vss sky130_fd_pr__res_high_po_1p41 l=3 mult=1
XR19 n20 n19 vss sky130_fd_pr__res_high_po_1p41 l=3 mult=1
XR20 n21 n20 vss sky130_fd_pr__res_high_po_1p41 l=3 mult=1
XR21 n22 n21 vss sky130_fd_pr__res_high_po_1p41 l=3 mult=1
XR22 n23 n22 vss sky130_fd_pr__res_high_po_1p41 l=3 mult=1
XR23 n24 n23 vss sky130_fd_pr__res_high_po_1p41 l=3 mult=1
XR24 n25 n24 vss sky130_fd_pr__res_high_po_1p41 l=3 mult=1
XR25 n26 n25 vss sky130_fd_pr__res_high_po_1p41 l=3 mult=1
XR26 n27 n26 vss sky130_fd_pr__res_high_po_1p41 l=3 mult=1
XR27 n28 n27 vss sky130_fd_pr__res_high_po_1p41 l=3 mult=1
XR28 n29 n28 vss sky130_fd_pr__res_high_po_1p41 l=3 mult=1
XR29 n30 n29 vss sky130_fd_pr__res_high_po_1p41 l=3 mult=1
XR30 n31 n30 vss sky130_fd_pr__res_high_po_1p41 l=3 mult=1
XR31 n32 n31 vss sky130_fd_pr__res_high_po_1p41 l=3 mult=1
XR32 n33 n32 vss sky130_fd_pr__res_high_po_1p41 l=3 mult=1
XR33 n34 n33 vss sky130_fd_pr__res_high_po_1p41 l=3 mult=1
XR34 n35 n34 vss sky130_fd_pr__res_high_po_1p41 l=3 mult=1
XR35 n36 n35 vss sky130_fd_pr__res_high_po_1p41 l=3 mult=1
XR36 n37 n36 vss sky130_fd_pr__res_high_po_1p41 l=3 mult=1
XR37 n38 n37 vss sky130_fd_pr__res_high_po_1p41 l=3 mult=1
XR38 n39 n38 vss sky130_fd_pr__res_high_po_1p41 l=3 mult=1
XR39 n40 n39 vss sky130_fd_pr__res_high_po_1p41 l=3 mult=1
XR40 n41 n40 vss sky130_fd_pr__res_high_po_1p41 l=3 mult=1
XR41 n42 n41 vss sky130_fd_pr__res_high_po_1p41 l=3 mult=1
XR42 n43 n42 vss sky130_fd_pr__res_high_po_1p41 l=3 mult=1
XR43 n44 n43 vss sky130_fd_pr__res_high_po_1p41 l=3 mult=1
XR44 n45 n44 vss sky130_fd_pr__res_high_po_1p41 l=3 mult=1
XR45 n46 n45 vss sky130_fd_pr__res_high_po_1p41 l=3 mult=1
XR46 n47 n46 vss sky130_fd_pr__res_high_po_1p41 l=3 mult=1
XR47 n48 n47 vss sky130_fd_pr__res_high_po_1p41 l=3 mult=1
XR48 n49 n48 vss sky130_fd_pr__res_high_po_1p41 l=3 mult=1
XR49 n50 n49 vss sky130_fd_pr__res_high_po_1p41 l=3 mult=1
XR50 n51 n50 vss sky130_fd_pr__res_high_po_1p41 l=3 mult=1
XR51 n52 n51 vss sky130_fd_pr__res_high_po_1p41 l=3 mult=1
XR52 n53 n52 vss sky130_fd_pr__res_high_po_1p41 l=3 mult=1
XR53 n54 n53 vss sky130_fd_pr__res_high_po_1p41 l=3 mult=1
XR54 n55 n54 vss sky130_fd_pr__res_high_po_1p41 l=3 mult=1
XR55 n56 n55 vss sky130_fd_pr__res_high_po_1p41 l=3 mult=1
XR56 n57 n56 vss sky130_fd_pr__res_high_po_1p41 l=3 mult=1
XR57 n58 n57 vss sky130_fd_pr__res_high_po_1p41 l=3 mult=1
XR58 n59 n58 vss sky130_fd_pr__res_high_po_1p41 l=3 mult=1
XR59 n60 n59 vss sky130_fd_pr__res_high_po_1p41 l=3 mult=1
XR60 n61 n60 vss sky130_fd_pr__res_high_po_1p41 l=3 mult=1
XR61 n62 n61 vss sky130_fd_pr__res_high_po_1p41 l=3 mult=1
XR62 n63 n62 vss sky130_fd_pr__res_high_po_1p41 l=3 mult=1
XR63 n64 n63 vss sky130_fd_pr__res_high_po_1p41 l=3 mult=1
XR64 n65 n64 vss sky130_fd_pr__res_high_po_1p41 l=3 mult=1
XR65 n66 n65 vss sky130_fd_pr__res_high_po_1p41 l=3 mult=1
XR66 n67 n66 vss sky130_fd_pr__res_high_po_1p41 l=3 mult=1
XR67 n68 n67 vss sky130_fd_pr__res_high_po_1p41 l=3 mult=1
XR68 n69 n68 vss sky130_fd_pr__res_high_po_1p41 l=3 mult=1
XR69 n70 n69 vss sky130_fd_pr__res_high_po_1p41 l=3 mult=1
XR70 n71 n70 vss sky130_fd_pr__res_high_po_1p41 l=3 mult=1
XR71 n72 n71 vss sky130_fd_pr__res_high_po_1p41 l=3 mult=1
XR72 n73 n72 vss sky130_fd_pr__res_high_po_1p41 l=3 mult=1
XR73 n74 n73 vss sky130_fd_pr__res_high_po_1p41 l=3 mult=1
XR74 n75 n74 vss sky130_fd_pr__res_high_po_1p41 l=3 mult=1
XR75 n76 n75 vss sky130_fd_pr__res_high_po_1p41 l=3 mult=1
XR76 n77 n76 vss sky130_fd_pr__res_high_po_1p41 l=3 mult=1
XR77 n78 n77 vss sky130_fd_pr__res_high_po_1p41 l=3 mult=1
XR78 n79 n78 vss sky130_fd_pr__res_high_po_1p41 l=3 mult=1
XR79 n80 n79 vss sky130_fd_pr__res_high_po_1p41 l=3 mult=1
XR80 n81 n80 vss sky130_fd_pr__res_high_po_1p41 l=3 mult=1
XR81 n82 n81 vss sky130_fd_pr__res_high_po_1p41 l=3 mult=1
XR82 n83 n82 vss sky130_fd_pr__res_high_po_1p41 l=3 mult=1
XR83 n84 n83 vss sky130_fd_pr__res_high_po_1p41 l=3 mult=1
XR84 n85 n84 vss sky130_fd_pr__res_high_po_1p41 l=3 mult=1
XR85 n86 n85 vss sky130_fd_pr__res_high_po_1p41 l=3 mult=1
XR86 n87 n86 vss sky130_fd_pr__res_high_po_1p41 l=3 mult=1
XR87 n88 n87 vss sky130_fd_pr__res_high_po_1p41 l=3 mult=1
XR88 n89 n88 vss sky130_fd_pr__res_high_po_1p41 l=3 mult=1
XR89 n90 n89 vss sky130_fd_pr__res_high_po_1p41 l=3 mult=1
XR90 n91 n90 vss sky130_fd_pr__res_high_po_1p41 l=3 mult=1
XR91 n92 n91 vss sky130_fd_pr__res_high_po_1p41 l=3 mult=1
XR92 n93 n92 vss sky130_fd_pr__res_high_po_1p41 l=3 mult=1
XR93 n94 n93 vss sky130_fd_pr__res_high_po_1p41 l=3 mult=1
XR94 n95 n94 vss sky130_fd_pr__res_high_po_1p41 l=3 mult=1
XR95 n96 n95 vss sky130_fd_pr__res_high_po_1p41 l=3 mult=1
XR96 n97 n96 vss sky130_fd_pr__res_high_po_1p41 l=3 mult=1
XR97 n98 n97 vss sky130_fd_pr__res_high_po_1p41 l=3 mult=1
XR98 n99 n98 vss sky130_fd_pr__res_high_po_1p41 l=3 mult=1
XR99 n100 n99 vss sky130_fd_pr__res_high_po_1p41 l=3 mult=1
XR100 n101 n100 vss sky130_fd_pr__res_high_po_1p41 l=3 mult=1
XR101 n102 n101 vss sky130_fd_pr__res_high_po_1p41 l=3 mult=1
XR102 n103 n102 vss sky130_fd_pr__res_high_po_1p41 l=3 mult=1
XR103 n104 n103 vss sky130_fd_pr__res_high_po_1p41 l=3 mult=1
XR104 n105 n104 vss sky130_fd_pr__res_high_po_1p41 l=3 mult=1
XR105 n106 n105 vss sky130_fd_pr__res_high_po_1p41 l=3 mult=1
XR106 n107 n106 vss sky130_fd_pr__res_high_po_1p41 l=3 mult=1
XR107 n108 n107 vss sky130_fd_pr__res_high_po_1p41 l=3 mult=1
XR108 n109 n108 vss sky130_fd_pr__res_high_po_1p41 l=3 mult=1
XR109 n110 n109 vss sky130_fd_pr__res_high_po_1p41 l=3 mult=1
XR110 n111 n110 vss sky130_fd_pr__res_high_po_1p41 l=3 mult=1
XR111 n112 n111 vss sky130_fd_pr__res_high_po_1p41 l=3 mult=1
XR112 n113 n112 vss sky130_fd_pr__res_high_po_1p41 l=3 mult=1
XR113 n114 n113 vss sky130_fd_pr__res_high_po_1p41 l=3 mult=1
XR114 n115 n114 vss sky130_fd_pr__res_high_po_1p41 l=3 mult=1
XR115 n116 n115 vss sky130_fd_pr__res_high_po_1p41 l=3 mult=1
XR116 n117 n116 vss sky130_fd_pr__res_high_po_1p41 l=3 mult=1
XR117 n118 n117 vss sky130_fd_pr__res_high_po_1p41 l=3 mult=1
XR118 n119 n118 vss sky130_fd_pr__res_high_po_1p41 l=3 mult=1
XR119 n120 n119 vss sky130_fd_pr__res_high_po_1p41 l=3 mult=1
XR120 n121 n120 vss sky130_fd_pr__res_high_po_1p41 l=3 mult=1
XR121 n122 n121 vss sky130_fd_pr__res_high_po_1p41 l=3 mult=1
XR122 n123 n122 vss sky130_fd_pr__res_high_po_1p41 l=3 mult=1
XR123 n124 n123 vss sky130_fd_pr__res_high_po_1p41 l=3 mult=1
XR124 n125 n124 vss sky130_fd_pr__res_high_po_1p41 l=3 mult=1
XR125 n126 n125 vss sky130_fd_pr__res_high_po_1p41 l=3 mult=1
XR126 n127 n126 vss sky130_fd_pr__res_high_po_1p41 l=3 mult=1
XR127 n128 n127 vss sky130_fd_pr__res_high_po_1p41 l=3 mult=1
XR128 n129 n128 vss sky130_fd_pr__res_high_po_1p41 l=3 mult=1
XR129 n130 n129 vss sky130_fd_pr__res_high_po_1p41 l=3 mult=1
XR130 n131 n130 vss sky130_fd_pr__res_high_po_1p41 l=3 mult=1
XR131 n132 n131 vss sky130_fd_pr__res_high_po_1p41 l=3 mult=1
XR132 n133 n132 vss sky130_fd_pr__res_high_po_1p41 l=3 mult=1
XR133 n134 n133 vss sky130_fd_pr__res_high_po_1p41 l=3 mult=1
XR134 n135 n134 vss sky130_fd_pr__res_high_po_1p41 l=3 mult=1
XR135 n136 n135 vss sky130_fd_pr__res_high_po_1p41 l=3 mult=1
XR136 n137 n136 vss sky130_fd_pr__res_high_po_1p41 l=3 mult=1
XR137 n138 n137 vss sky130_fd_pr__res_high_po_1p41 l=3 mult=1
XR138 n139 n138 vss sky130_fd_pr__res_high_po_1p41 l=3 mult=1
XR139 n140 n139 vss sky130_fd_pr__res_high_po_1p41 l=3 mult=1
XR140 n141 n140 vss sky130_fd_pr__res_high_po_1p41 l=3 mult=1
XR141 n142 n141 vss sky130_fd_pr__res_high_po_1p41 l=3 mult=1
XR142 n143 n142 vss sky130_fd_pr__res_high_po_1p41 l=3 mult=1
XR143 n144 n143 vss sky130_fd_pr__res_high_po_1p41 l=3 mult=1
XR144 n145 n144 vss sky130_fd_pr__res_high_po_1p41 l=3 mult=1
XR145 n146 n145 vss sky130_fd_pr__res_high_po_1p41 l=3 mult=1
XR146 n147 n146 vss sky130_fd_pr__res_high_po_1p41 l=3 mult=1
XR147 n148 n147 vss sky130_fd_pr__res_high_po_1p41 l=3 mult=1
XR148 n149 n148 vss sky130_fd_pr__res_high_po_1p41 l=3 mult=1
XR149 n150 n149 vss sky130_fd_pr__res_high_po_1p41 l=3 mult=1
XR150 n151 n150 vss sky130_fd_pr__res_high_po_1p41 l=3 mult=1
XR151 n152 n151 vss sky130_fd_pr__res_high_po_1p41 l=3 mult=1
XR152 n153 n152 vss sky130_fd_pr__res_high_po_1p41 l=3 mult=1
XR153 n154 n153 vss sky130_fd_pr__res_high_po_1p41 l=3 mult=1
XR154 n155 n154 vss sky130_fd_pr__res_high_po_1p41 l=3 mult=1
XR155 n156 n155 vss sky130_fd_pr__res_high_po_1p41 l=3 mult=1
XR156 n157 n156 vss sky130_fd_pr__res_high_po_1p41 l=3 mult=1
XR157 n158 n157 vss sky130_fd_pr__res_high_po_1p41 l=3 mult=1
XR158 n159 n158 vss sky130_fd_pr__res_high_po_1p41 l=3 mult=1
XR159 n160 n159 vss sky130_fd_pr__res_high_po_1p41 l=3 mult=1
XR160 n161 n160 vss sky130_fd_pr__res_high_po_1p41 l=3 mult=1
XR161 n162 n161 vss sky130_fd_pr__res_high_po_1p41 l=3 mult=1
XR162 n163 n162 vss sky130_fd_pr__res_high_po_1p41 l=3 mult=1
XR163 n164 n163 vss sky130_fd_pr__res_high_po_1p41 l=3 mult=1
XR164 n165 n164 vss sky130_fd_pr__res_high_po_1p41 l=3 mult=1
XR165 n166 n165 vss sky130_fd_pr__res_high_po_1p41 l=3 mult=1
XR166 n167 n166 vss sky130_fd_pr__res_high_po_1p41 l=3 mult=1
XR167 n168 n167 vss sky130_fd_pr__res_high_po_1p41 l=3 mult=1
XR168 n169 n168 vss sky130_fd_pr__res_high_po_1p41 l=3 mult=1
XR169 n170 n169 vss sky130_fd_pr__res_high_po_1p41 l=3 mult=1
XR170 n171 n170 vss sky130_fd_pr__res_high_po_1p41 l=3 mult=1
XR171 n172 n171 vss sky130_fd_pr__res_high_po_1p41 l=3 mult=1
XR172 n173 n172 vss sky130_fd_pr__res_high_po_1p41 l=3 mult=1
XR173 n174 n173 vss sky130_fd_pr__res_high_po_1p41 l=3 mult=1
XR174 n175 n174 vss sky130_fd_pr__res_high_po_1p41 l=3 mult=1
XR175 n176 n175 vss sky130_fd_pr__res_high_po_1p41 l=3 mult=1
XR176 n177 n176 vss sky130_fd_pr__res_high_po_1p41 l=3 mult=1
XR177 n178 n177 vss sky130_fd_pr__res_high_po_1p41 l=3 mult=1
XR178 n179 n178 vss sky130_fd_pr__res_high_po_1p41 l=3 mult=1
XR179 n180 n179 vss sky130_fd_pr__res_high_po_1p41 l=3 mult=1
XR180 n181 n180 vss sky130_fd_pr__res_high_po_1p41 l=3 mult=1
XR181 n182 n181 vss sky130_fd_pr__res_high_po_1p41 l=3 mult=1
XR182 n183 n182 vss sky130_fd_pr__res_high_po_1p41 l=3 mult=1
XR183 n184 n183 vss sky130_fd_pr__res_high_po_1p41 l=3 mult=1
XR184 n185 n184 vss sky130_fd_pr__res_high_po_1p41 l=3 mult=1
XR185 n186 n185 vss sky130_fd_pr__res_high_po_1p41 l=3 mult=1
XR186 n187 n186 vss sky130_fd_pr__res_high_po_1p41 l=3 mult=1
XR187 n188 n187 vss sky130_fd_pr__res_high_po_1p41 l=3 mult=1
XR188 n189 n188 vss sky130_fd_pr__res_high_po_1p41 l=3 mult=1
XR189 n190 n189 vss sky130_fd_pr__res_high_po_1p41 l=3 mult=1
XR190 n191 n190 vss sky130_fd_pr__res_high_po_1p41 l=3 mult=1
XR191 n192 n191 vss sky130_fd_pr__res_high_po_1p41 l=3 mult=1
XR192 n193 n192 vss sky130_fd_pr__res_high_po_1p41 l=3 mult=1
XR193 n194 n193 vss sky130_fd_pr__res_high_po_1p41 l=3 mult=1
XR194 n195 n194 vss sky130_fd_pr__res_high_po_1p41 l=3 mult=1
XR195 n196 n195 vss sky130_fd_pr__res_high_po_1p41 l=3 mult=1
XR196 n197 n196 vss sky130_fd_pr__res_high_po_1p41 l=3 mult=1
XR197 n198 n197 vss sky130_fd_pr__res_high_po_1p41 l=3 mult=1
XR198 n199 n198 vss sky130_fd_pr__res_high_po_1p41 l=3 mult=1
XR199 n200 n199 vss sky130_fd_pr__res_high_po_1p41 l=3 mult=1
XR200 n201 n200 vss sky130_fd_pr__res_high_po_1p41 l=3 mult=1
XR201 n202 n201 vss sky130_fd_pr__res_high_po_1p41 l=3 mult=1
XR202 n203 n202 vss sky130_fd_pr__res_high_po_1p41 l=3 mult=1
XR203 n204 n203 vss sky130_fd_pr__res_high_po_1p41 l=3 mult=1
XR204 n205 n204 vss sky130_fd_pr__res_high_po_1p41 l=3 mult=1
XR205 n206 n205 vss sky130_fd_pr__res_high_po_1p41 l=3 mult=1
XR206 n207 n206 vss sky130_fd_pr__res_high_po_1p41 l=3 mult=1
XR207 n208 n207 vss sky130_fd_pr__res_high_po_1p41 l=3 mult=1
XR208 n209 n208 vss sky130_fd_pr__res_high_po_1p41 l=3 mult=1
XR209 n210 n209 vss sky130_fd_pr__res_high_po_1p41 l=3 mult=1
XR210 n211 n210 vss sky130_fd_pr__res_high_po_1p41 l=3 mult=1
XR211 n212 n211 vss sky130_fd_pr__res_high_po_1p41 l=3 mult=1
XR212 n213 n212 vss sky130_fd_pr__res_high_po_1p41 l=3 mult=1
XR213 n214 n213 vss sky130_fd_pr__res_high_po_1p41 l=3 mult=1
XR214 n215 n214 vss sky130_fd_pr__res_high_po_1p41 l=3 mult=1
XR215 n216 n215 vss sky130_fd_pr__res_high_po_1p41 l=3 mult=1
XR216 n217 n216 vss sky130_fd_pr__res_high_po_1p41 l=3 mult=1
XR217 n218 n217 vss sky130_fd_pr__res_high_po_1p41 l=3 mult=1
XR218 n219 n218 vss sky130_fd_pr__res_high_po_1p41 l=3 mult=1
XR219 n220 n219 vss sky130_fd_pr__res_high_po_1p41 l=3 mult=1
XR220 n221 n220 vss sky130_fd_pr__res_high_po_1p41 l=3 mult=1
XR221 n222 n221 vss sky130_fd_pr__res_high_po_1p41 l=3 mult=1
XR222 n223 n222 vss sky130_fd_pr__res_high_po_1p41 l=3 mult=1
XR223 n224 n223 vss sky130_fd_pr__res_high_po_1p41 l=3 mult=1
XR224 n225 n224 vss sky130_fd_pr__res_high_po_1p41 l=3 mult=1
XR225 n226 n225 vss sky130_fd_pr__res_high_po_1p41 l=3 mult=1
XR226 n227 n226 vss sky130_fd_pr__res_high_po_1p41 l=3 mult=1
XR227 n228 n227 vss sky130_fd_pr__res_high_po_1p41 l=3 mult=1
XR228 n229 n228 vss sky130_fd_pr__res_high_po_1p41 l=3 mult=1
XR229 n230 n229 vss sky130_fd_pr__res_high_po_1p41 l=3 mult=1
XR230 n231 n230 vss sky130_fd_pr__res_high_po_1p41 l=3 mult=1
XR231 n232 n231 vss sky130_fd_pr__res_high_po_1p41 l=3 mult=1
XR232 n233 n232 vss sky130_fd_pr__res_high_po_1p41 l=3 mult=1
XR233 n234 n233 vss sky130_fd_pr__res_high_po_1p41 l=3 mult=1
XR234 n235 n234 vss sky130_fd_pr__res_high_po_1p41 l=3 mult=1
XR235 n236 n235 vss sky130_fd_pr__res_high_po_1p41 l=3 mult=1
XR236 n237 n236 vss sky130_fd_pr__res_high_po_1p41 l=3 mult=1
XR237 n238 n237 vss sky130_fd_pr__res_high_po_1p41 l=3 mult=1
XR238 n239 n238 vss sky130_fd_pr__res_high_po_1p41 l=3 mult=1
XR239 n240 n239 vss sky130_fd_pr__res_high_po_1p41 l=3 mult=1
XR240 n241 n240 vss sky130_fd_pr__res_high_po_1p41 l=3 mult=1
XR241 n242 n241 vss sky130_fd_pr__res_high_po_1p41 l=3 mult=1
XR242 n243 n242 vss sky130_fd_pr__res_high_po_1p41 l=3 mult=1
XR243 n244 n243 vss sky130_fd_pr__res_high_po_1p41 l=3 mult=1
XR244 n245 n244 vss sky130_fd_pr__res_high_po_1p41 l=3 mult=1
XR245 n246 n245 vss sky130_fd_pr__res_high_po_1p41 l=3 mult=1
XR246 n247 n246 vss sky130_fd_pr__res_high_po_1p41 l=3 mult=1
XR247 n248 n247 vss sky130_fd_pr__res_high_po_1p41 l=3 mult=1
XR248 n249 n248 vss sky130_fd_pr__res_high_po_1p41 l=3 mult=1
XR249 n250 n249 vss sky130_fd_pr__res_high_po_1p41 l=3 mult=1
XR250 n251 n250 vss sky130_fd_pr__res_high_po_1p41 l=3 mult=1
XR251 n252 n251 vss sky130_fd_pr__res_high_po_1p41 l=3 mult=1
XR252 n253 n252 vss sky130_fd_pr__res_high_po_1p41 l=3 mult=1
XR253 n254 n253 vss sky130_fd_pr__res_high_po_1p41 l=3 mult=1
XR254 n255 n254 vss sky130_fd_pr__res_high_po_1p41 l=3 mult=1
XR255 n256 n255 vss sky130_fd_pr__res_high_po_1p41 l=3 mult=1
XR256 n257 n256 vss sky130_fd_pr__res_high_po_1p41 l=3 mult=1
XR257 n258 n257 vss sky130_fd_pr__res_high_po_1p41 l=3 mult=1
XR258 n259 n258 vss sky130_fd_pr__res_high_po_1p41 l=3 mult=1
XR259 n260 n259 vss sky130_fd_pr__res_high_po_1p41 l=3 mult=1
XR260 n261 n260 vss sky130_fd_pr__res_high_po_1p41 l=3 mult=1
XR261 n262 n261 vss sky130_fd_pr__res_high_po_1p41 l=3 mult=1
XR262 n263 n262 vss sky130_fd_pr__res_high_po_1p41 l=3 mult=1
XR263 n264 n263 vss sky130_fd_pr__res_high_po_1p41 l=3 mult=1
XR264 n265 n264 vss sky130_fd_pr__res_high_po_1p41 l=3 mult=1
XR265 n266 n265 vss sky130_fd_pr__res_high_po_1p41 l=3 mult=1
XR266 n267 n266 vss sky130_fd_pr__res_high_po_1p41 l=3 mult=1
XR267 n268 n267 vss sky130_fd_pr__res_high_po_1p41 l=3 mult=1
XR268 n269 n268 vss sky130_fd_pr__res_high_po_1p41 l=3 mult=1
XR269 n270 n269 vss sky130_fd_pr__res_high_po_1p41 l=3 mult=1
XR270 n271 n270 vss sky130_fd_pr__res_high_po_1p41 l=3 mult=1
XR271 n272 n271 vss sky130_fd_pr__res_high_po_1p41 l=3 mult=1
XR272 n273 n272 vss sky130_fd_pr__res_high_po_1p41 l=3 mult=1
XR273 n274 n273 vss sky130_fd_pr__res_high_po_1p41 l=3 mult=1
XR274 n275 n274 vss sky130_fd_pr__res_high_po_1p41 l=3 mult=1
XR275 n276 n275 vss sky130_fd_pr__res_high_po_1p41 l=3 mult=1
XR276 n277 n276 vss sky130_fd_pr__res_high_po_1p41 l=3 mult=1
XR277 n278 n277 vss sky130_fd_pr__res_high_po_1p41 l=3 mult=1
XR278 n279 n278 vss sky130_fd_pr__res_high_po_1p41 l=3 mult=1
XR279 n280 n279 vss sky130_fd_pr__res_high_po_1p41 l=3 mult=1
XR280 n281 n280 vss sky130_fd_pr__res_high_po_1p41 l=3 mult=1
XR281 n282 n281 vss sky130_fd_pr__res_high_po_1p41 l=3 mult=1
XR282 n283 n282 vss sky130_fd_pr__res_high_po_1p41 l=3 mult=1
XR283 n284 n283 vss sky130_fd_pr__res_high_po_1p41 l=3 mult=1
XR284 n285 n284 vss sky130_fd_pr__res_high_po_1p41 l=3 mult=1
XR285 n286 n285 vss sky130_fd_pr__res_high_po_1p41 l=3 mult=1
XR286 n287 n286 vss sky130_fd_pr__res_high_po_1p41 l=3 mult=1
XR287 n288 n287 vss sky130_fd_pr__res_high_po_1p41 l=3 mult=1
XR288 n289 n288 vss sky130_fd_pr__res_high_po_1p41 l=3 mult=1
XR289 n290 n289 vss sky130_fd_pr__res_high_po_1p41 l=3 mult=1
XR290 n291 n290 vss sky130_fd_pr__res_high_po_1p41 l=3 mult=1
XR291 n292 n291 vss sky130_fd_pr__res_high_po_1p41 l=3 mult=1
XR292 n293 n292 vss sky130_fd_pr__res_high_po_1p41 l=3 mult=1
XR293 n294 n293 vss sky130_fd_pr__res_high_po_1p41 l=3 mult=1
XR294 n295 n294 vss sky130_fd_pr__res_high_po_1p41 l=3 mult=1
XR295 n296 n295 vss sky130_fd_pr__res_high_po_1p41 l=3 mult=1
XR296 n297 n296 vss sky130_fd_pr__res_high_po_1p41 l=3 mult=1
XR297 n298 n297 vss sky130_fd_pr__res_high_po_1p41 l=3 mult=1
XR298 n299 n298 vss sky130_fd_pr__res_high_po_1p41 l=3 mult=1
XR299 n300 n299 vss sky130_fd_pr__res_high_po_1p41 l=3 mult=1
XR300 n301 n300 vss sky130_fd_pr__res_high_po_1p41 l=3 mult=1
XR301 n302 n301 vss sky130_fd_pr__res_high_po_1p41 l=3 mult=1
XR302 n303 n302 vss sky130_fd_pr__res_high_po_1p41 l=3 mult=1
XR303 n304 n303 vss sky130_fd_pr__res_high_po_1p41 l=3 mult=1
XR304 n305 n304 vss sky130_fd_pr__res_high_po_1p41 l=3 mult=1
XR305 n306 n305 vss sky130_fd_pr__res_high_po_1p41 l=3 mult=1
XR306 n307 n306 vss sky130_fd_pr__res_high_po_1p41 l=3 mult=1
XR307 n308 n307 vss sky130_fd_pr__res_high_po_1p41 l=3 mult=1
XR308 n309 n308 vss sky130_fd_pr__res_high_po_1p41 l=3 mult=1
XR309 n310 n309 vss sky130_fd_pr__res_high_po_1p41 l=3 mult=1
XR310 n311 n310 vss sky130_fd_pr__res_high_po_1p41 l=3 mult=1
XR311 n312 n311 vss sky130_fd_pr__res_high_po_1p41 l=3 mult=1
XR312 n313 n312 vss sky130_fd_pr__res_high_po_1p41 l=3 mult=1
XR313 n314 n313 vss sky130_fd_pr__res_high_po_1p41 l=3 mult=1
XR314 n315 n314 vss sky130_fd_pr__res_high_po_1p41 l=3 mult=1
XR315 n316 n315 vss sky130_fd_pr__res_high_po_1p41 l=3 mult=1
XR316 n317 n316 vss sky130_fd_pr__res_high_po_1p41 l=3 mult=1
XR317 n318 n317 vss sky130_fd_pr__res_high_po_1p41 l=3 mult=1
XR318 n319 n318 vss sky130_fd_pr__res_high_po_1p41 l=3 mult=1
XR319 n320 n319 vss sky130_fd_pr__res_high_po_1p41 l=3 mult=1
XR320 n321 n320 vss sky130_fd_pr__res_high_po_1p41 l=3 mult=1
XR321 n322 n321 vss sky130_fd_pr__res_high_po_1p41 l=3 mult=1
XR322 n323 n322 vss sky130_fd_pr__res_high_po_1p41 l=3 mult=1
XR323 n324 n323 vss sky130_fd_pr__res_high_po_1p41 l=3 mult=1
XR324 n325 n324 vss sky130_fd_pr__res_high_po_1p41 l=3 mult=1
XR325 n326 n325 vss sky130_fd_pr__res_high_po_1p41 l=3 mult=1
XR326 n327 n326 vss sky130_fd_pr__res_high_po_1p41 l=3 mult=1
XR327 n328 n327 vss sky130_fd_pr__res_high_po_1p41 l=3 mult=1
XR328 n329 n328 vss sky130_fd_pr__res_high_po_1p41 l=3 mult=1
XR329 n330 n329 vss sky130_fd_pr__res_high_po_1p41 l=3 mult=1
XR330 n331 n330 vss sky130_fd_pr__res_high_po_1p41 l=3 mult=1
XR331 n332 n331 vss sky130_fd_pr__res_high_po_1p41 l=3 mult=1
XR332 n333 n332 vss sky130_fd_pr__res_high_po_1p41 l=3 mult=1
XR333 n334 n333 vss sky130_fd_pr__res_high_po_1p41 l=3 mult=1
XR334 n335 n334 vss sky130_fd_pr__res_high_po_1p41 l=3 mult=1
XR335 n336 n335 vss sky130_fd_pr__res_high_po_1p41 l=3 mult=1
XR336 n337 n336 vss sky130_fd_pr__res_high_po_1p41 l=3 mult=1
XR337 n338 n337 vss sky130_fd_pr__res_high_po_1p41 l=3 mult=1
XR338 n339 n338 vss sky130_fd_pr__res_high_po_1p41 l=3 mult=1
XR339 n340 n339 vss sky130_fd_pr__res_high_po_1p41 l=3 mult=1
XR340 n341 n340 vss sky130_fd_pr__res_high_po_1p41 l=3 mult=1
XR341 n342 n341 vss sky130_fd_pr__res_high_po_1p41 l=3 mult=1
XR342 n343 n342 vss sky130_fd_pr__res_high_po_1p41 l=3 mult=1
XR343 n344 n343 vss sky130_fd_pr__res_high_po_1p41 l=3 mult=1
XR344 n345 n344 vss sky130_fd_pr__res_high_po_1p41 l=3 mult=1
XR345 n346 n345 vss sky130_fd_pr__res_high_po_1p41 l=3 mult=1
XR346 n347 n346 vss sky130_fd_pr__res_high_po_1p41 l=3 mult=1
XR347 n348 n347 vss sky130_fd_pr__res_high_po_1p41 l=3 mult=1
XR348 n349 n348 vss sky130_fd_pr__res_high_po_1p41 l=3 mult=1
XR349 n350 n349 vss sky130_fd_pr__res_high_po_1p41 l=3 mult=1
XR350 n351 n350 vss sky130_fd_pr__res_high_po_1p41 l=3 mult=1
XR351 n352 n351 vss sky130_fd_pr__res_high_po_1p41 l=3 mult=1
XR352 n353 n352 vss sky130_fd_pr__res_high_po_1p41 l=3 mult=1
XR353 n354 n353 vss sky130_fd_pr__res_high_po_1p41 l=3 mult=1
XR354 n355 n354 vss sky130_fd_pr__res_high_po_1p41 l=3 mult=1
XR355 n356 n355 vss sky130_fd_pr__res_high_po_1p41 l=3 mult=1
XR356 n357 n356 vss sky130_fd_pr__res_high_po_1p41 l=3 mult=1
XR357 n358 n357 vss sky130_fd_pr__res_high_po_1p41 l=3 mult=1
XR358 n359 n358 vss sky130_fd_pr__res_high_po_1p41 l=3 mult=1
XR359 n360 n359 vss sky130_fd_pr__res_high_po_1p41 l=3 mult=1
XR360 n361 n360 vss sky130_fd_pr__res_high_po_1p41 l=3 mult=1
XR361 n362 n361 vss sky130_fd_pr__res_high_po_1p41 l=3 mult=1
XR362 n363 n362 vss sky130_fd_pr__res_high_po_1p41 l=3 mult=1
XR363 n364 n363 vss sky130_fd_pr__res_high_po_1p41 l=3 mult=1
XR364 n365 n364 vss sky130_fd_pr__res_high_po_1p41 l=3 mult=1
XR365 n366 n365 vss sky130_fd_pr__res_high_po_1p41 l=3 mult=1
XR366 n367 n366 vss sky130_fd_pr__res_high_po_1p41 l=3 mult=1
XR367 n368 n367 vss sky130_fd_pr__res_high_po_1p41 l=3 mult=1
XR368 n369 n368 vss sky130_fd_pr__res_high_po_1p41 l=3 mult=1
XR369 n370 n369 vss sky130_fd_pr__res_high_po_1p41 l=3 mult=1
XR370 n371 n370 vss sky130_fd_pr__res_high_po_1p41 l=3 mult=1
XR371 n372 n371 vss sky130_fd_pr__res_high_po_1p41 l=3 mult=1
XR372 n373 n372 vss sky130_fd_pr__res_high_po_1p41 l=3 mult=1
XR373 n374 n373 vss sky130_fd_pr__res_high_po_1p41 l=3 mult=1
XR374 n375 n374 vss sky130_fd_pr__res_high_po_1p41 l=3 mult=1
XR375 n376 n375 vss sky130_fd_pr__res_high_po_1p41 l=3 mult=1
XR376 n377 n376 vss sky130_fd_pr__res_high_po_1p41 l=3 mult=1
XR377 n378 n377 vss sky130_fd_pr__res_high_po_1p41 l=3 mult=1
XR378 n379 n378 vss sky130_fd_pr__res_high_po_1p41 l=3 mult=1
XR379 n380 n379 vss sky130_fd_pr__res_high_po_1p41 l=3 mult=1
XR380 n381 n380 vss sky130_fd_pr__res_high_po_1p41 l=3 mult=1
XR381 n382 n381 vss sky130_fd_pr__res_high_po_1p41 l=3 mult=1
XR382 n383 n382 vss sky130_fd_pr__res_high_po_1p41 l=3 mult=1
XR383 n384 n383 vss sky130_fd_pr__res_high_po_1p41 l=3 mult=1
XR384 n385 n384 vss sky130_fd_pr__res_high_po_1p41 l=3 mult=1
XR385 n386 n385 vss sky130_fd_pr__res_high_po_1p41 l=3 mult=1
XR386 n387 n386 vss sky130_fd_pr__res_high_po_1p41 l=3 mult=1
XR387 n388 n387 vss sky130_fd_pr__res_high_po_1p41 l=3 mult=1
XR388 n389 n388 vss sky130_fd_pr__res_high_po_1p41 l=3 mult=1
XR389 n390 n389 vss sky130_fd_pr__res_high_po_1p41 l=3 mult=1
XR390 n391 n390 vss sky130_fd_pr__res_high_po_1p41 l=3 mult=1
XR391 n392 n391 vss sky130_fd_pr__res_high_po_1p41 l=3 mult=1
XR392 n393 n392 vss sky130_fd_pr__res_high_po_1p41 l=3 mult=1
XR393 n394 n393 vss sky130_fd_pr__res_high_po_1p41 l=3 mult=1
XR394 n395 n394 vss sky130_fd_pr__res_high_po_1p41 l=3 mult=1
XR395 n396 n395 vss sky130_fd_pr__res_high_po_1p41 l=3 mult=1
XR396 n397 n396 vss sky130_fd_pr__res_high_po_1p41 l=3 mult=1
XR397 n398 n397 vss sky130_fd_pr__res_high_po_1p41 l=3 mult=1
XR398 n399 n398 vss sky130_fd_pr__res_high_po_1p41 l=3 mult=1
XR399 n400 n399 vss sky130_fd_pr__res_high_po_1p41 l=3 mult=1
XR400 n401 n400 vss sky130_fd_pr__res_high_po_1p41 l=3 mult=1
XR401 n402 n401 vss sky130_fd_pr__res_high_po_1p41 l=3 mult=1
XR402 n403 n402 vss sky130_fd_pr__res_high_po_1p41 l=3 mult=1
XR403 n404 n403 vss sky130_fd_pr__res_high_po_1p41 l=3 mult=1
XR404 n405 n404 vss sky130_fd_pr__res_high_po_1p41 l=3 mult=1
XR405 n406 n405 vss sky130_fd_pr__res_high_po_1p41 l=3 mult=1
XR406 n407 n406 vss sky130_fd_pr__res_high_po_1p41 l=3 mult=1
XR407 n408 n407 vss sky130_fd_pr__res_high_po_1p41 l=3 mult=1
XR408 n409 n408 vss sky130_fd_pr__res_high_po_1p41 l=3 mult=1
XR409 n410 n409 vss sky130_fd_pr__res_high_po_1p41 l=3 mult=1
XR410 n411 n410 vss sky130_fd_pr__res_high_po_1p41 l=3 mult=1
XR411 n412 n411 vss sky130_fd_pr__res_high_po_1p41 l=3 mult=1
XR412 n413 n412 vss sky130_fd_pr__res_high_po_1p41 l=3 mult=1
XR413 n414 n413 vss sky130_fd_pr__res_high_po_1p41 l=3 mult=1
XR414 n415 n414 vss sky130_fd_pr__res_high_po_1p41 l=3 mult=1
XR415 n416 n415 vss sky130_fd_pr__res_high_po_1p41 l=3 mult=1
XR416 n417 n416 vss sky130_fd_pr__res_high_po_1p41 l=3 mult=1
XR417 n418 n417 vss sky130_fd_pr__res_high_po_1p41 l=3 mult=1
XR418 n419 n418 vss sky130_fd_pr__res_high_po_1p41 l=3 mult=1
XR419 n420 n419 vss sky130_fd_pr__res_high_po_1p41 l=3 mult=1
XR420 n421 n420 vss sky130_fd_pr__res_high_po_1p41 l=3 mult=1
XR421 n422 n421 vss sky130_fd_pr__res_high_po_1p41 l=3 mult=1
XR422 n423 n422 vss sky130_fd_pr__res_high_po_1p41 l=3 mult=1
XR423 n424 n423 vss sky130_fd_pr__res_high_po_1p41 l=3 mult=1
XR424 n425 n424 vss sky130_fd_pr__res_high_po_1p41 l=3 mult=1
XR425 n426 n425 vss sky130_fd_pr__res_high_po_1p41 l=3 mult=1
XR426 n427 n426 vss sky130_fd_pr__res_high_po_1p41 l=3 mult=1
XR427 n428 n427 vss sky130_fd_pr__res_high_po_1p41 l=3 mult=1
XR428 n429 n428 vss sky130_fd_pr__res_high_po_1p41 l=3 mult=1
XR429 n430 n429 vss sky130_fd_pr__res_high_po_1p41 l=3 mult=1
XR430 n431 n430 vss sky130_fd_pr__res_high_po_1p41 l=3 mult=1
XR431 n432 n431 vss sky130_fd_pr__res_high_po_1p41 l=3 mult=1
XR432 n433 n432 vss sky130_fd_pr__res_high_po_1p41 l=3 mult=1
XR433 n434 n433 vss sky130_fd_pr__res_high_po_1p41 l=3 mult=1
XR434 n435 n434 vss sky130_fd_pr__res_high_po_1p41 l=3 mult=1
XR435 n436 n435 vss sky130_fd_pr__res_high_po_1p41 l=3 mult=1
XR436 n437 n436 vss sky130_fd_pr__res_high_po_1p41 l=3 mult=1
XR437 n438 n437 vss sky130_fd_pr__res_high_po_1p41 l=3 mult=1
XR438 n439 n438 vss sky130_fd_pr__res_high_po_1p41 l=3 mult=1
XR439 n440 n439 vss sky130_fd_pr__res_high_po_1p41 l=3 mult=1
XR440 n441 n440 vss sky130_fd_pr__res_high_po_1p41 l=3 mult=1
XR441 n442 n441 vss sky130_fd_pr__res_high_po_1p41 l=3 mult=1
XR442 n443 n442 vss sky130_fd_pr__res_high_po_1p41 l=3 mult=1
XR443 n444 n443 vss sky130_fd_pr__res_high_po_1p41 l=3 mult=1
XR444 n445 n444 vss sky130_fd_pr__res_high_po_1p41 l=3 mult=1
XR445 n446 n445 vss sky130_fd_pr__res_high_po_1p41 l=3 mult=1
XR446 n447 n446 vss sky130_fd_pr__res_high_po_1p41 l=3 mult=1
XR447 n448 n447 vss sky130_fd_pr__res_high_po_1p41 l=3 mult=1
XR448 n449 n448 vss sky130_fd_pr__res_high_po_1p41 l=3 mult=1
XR449 n450 n449 vss sky130_fd_pr__res_high_po_1p41 l=3 mult=1
XR450 n451 n450 vss sky130_fd_pr__res_high_po_1p41 l=3 mult=1
XR451 n452 n451 vss sky130_fd_pr__res_high_po_1p41 l=3 mult=1
XR452 n453 n452 vss sky130_fd_pr__res_high_po_1p41 l=3 mult=1
XR453 n454 n453 vss sky130_fd_pr__res_high_po_1p41 l=3 mult=1
XR454 n455 n454 vss sky130_fd_pr__res_high_po_1p41 l=3 mult=1
XR455 n456 n455 vss sky130_fd_pr__res_high_po_1p41 l=3 mult=1
XR456 n457 n456 vss sky130_fd_pr__res_high_po_1p41 l=3 mult=1
XR457 n458 n457 vss sky130_fd_pr__res_high_po_1p41 l=3 mult=1
XR458 n459 n458 vss sky130_fd_pr__res_high_po_1p41 l=3 mult=1
XR459 n460 n459 vss sky130_fd_pr__res_high_po_1p41 l=3 mult=1
XR460 n461 n460 vss sky130_fd_pr__res_high_po_1p41 l=3 mult=1
XR461 n462 n461 vss sky130_fd_pr__res_high_po_1p41 l=3 mult=1
XR462 n463 n462 vss sky130_fd_pr__res_high_po_1p41 l=3 mult=1
XR463 n464 n463 vss sky130_fd_pr__res_high_po_1p41 l=3 mult=1
XR464 n465 n464 vss sky130_fd_pr__res_high_po_1p41 l=3 mult=1
XR465 n466 n465 vss sky130_fd_pr__res_high_po_1p41 l=3 mult=1
XR466 n467 n466 vss sky130_fd_pr__res_high_po_1p41 l=3 mult=1
XR467 n468 n467 vss sky130_fd_pr__res_high_po_1p41 l=3 mult=1
XR468 n469 n468 vss sky130_fd_pr__res_high_po_1p41 l=3 mult=1
XR469 n470 n469 vss sky130_fd_pr__res_high_po_1p41 l=3 mult=1
XR470 n471 n470 vss sky130_fd_pr__res_high_po_1p41 l=3 mult=1
XR471 n472 n471 vss sky130_fd_pr__res_high_po_1p41 l=3 mult=1
XR472 n473 n472 vss sky130_fd_pr__res_high_po_1p41 l=3 mult=1
XR473 n474 n473 vss sky130_fd_pr__res_high_po_1p41 l=3 mult=1
XR474 n475 n474 vss sky130_fd_pr__res_high_po_1p41 l=3 mult=1
XR475 n476 n475 vss sky130_fd_pr__res_high_po_1p41 l=3 mult=1
XR476 n477 n476 vss sky130_fd_pr__res_high_po_1p41 l=3 mult=1
XR477 n478 n477 vss sky130_fd_pr__res_high_po_1p41 l=3 mult=1
XR478 n479 n478 vss sky130_fd_pr__res_high_po_1p41 l=3 mult=1
XR479 n480 n479 vss sky130_fd_pr__res_high_po_1p41 l=3 mult=1
XR480 n481 n480 vss sky130_fd_pr__res_high_po_1p41 l=3 mult=1
XR481 n482 n481 vss sky130_fd_pr__res_high_po_1p41 l=3 mult=1
XR482 n483 n482 vss sky130_fd_pr__res_high_po_1p41 l=3 mult=1
XR483 n484 n483 vss sky130_fd_pr__res_high_po_1p41 l=3 mult=1
XR484 n485 n484 vss sky130_fd_pr__res_high_po_1p41 l=3 mult=1
XR485 n486 n485 vss sky130_fd_pr__res_high_po_1p41 l=3 mult=1
XR486 n487 n486 vss sky130_fd_pr__res_high_po_1p41 l=3 mult=1
XR487 n488 n487 vss sky130_fd_pr__res_high_po_1p41 l=3 mult=1
XR488 n489 n488 vss sky130_fd_pr__res_high_po_1p41 l=3 mult=1
XR489 n490 n489 vss sky130_fd_pr__res_high_po_1p41 l=3 mult=1
XR490 n491 n490 vss sky130_fd_pr__res_high_po_1p41 l=3 mult=1
XR491 n492 n491 vss sky130_fd_pr__res_high_po_1p41 l=3 mult=1
XR492 n493 n492 vss sky130_fd_pr__res_high_po_1p41 l=3 mult=1
XR493 n494 n493 vss sky130_fd_pr__res_high_po_1p41 l=3 mult=1
XR494 n495 n494 vss sky130_fd_pr__res_high_po_1p41 l=3 mult=1
XR495 n496 n495 vss sky130_fd_pr__res_high_po_1p41 l=3 mult=1
XR496 n497 n496 vss sky130_fd_pr__res_high_po_1p41 l=3 mult=1
XR497 n498 n497 vss sky130_fd_pr__res_high_po_1p41 l=3 mult=1
XR498 n499 n498 vss sky130_fd_pr__res_high_po_1p41 l=3 mult=1
XR499 n500 n499 vss sky130_fd_pr__res_high_po_1p41 l=3 mult=1
XR500 n501 n500 vss sky130_fd_pr__res_high_po_1p41 l=3 mult=1
XR501 n502 n501 vss sky130_fd_pr__res_high_po_1p41 l=3 mult=1
XR502 n503 n502 vss sky130_fd_pr__res_high_po_1p41 l=3 mult=1
XR503 n504 n503 vss sky130_fd_pr__res_high_po_1p41 l=3 mult=1
XR504 n505 n504 vss sky130_fd_pr__res_high_po_1p41 l=3 mult=1
XR505 n506 n505 vss sky130_fd_pr__res_high_po_1p41 l=3 mult=1
XR506 n507 n506 vss sky130_fd_pr__res_high_po_1p41 l=3 mult=1
XR507 n508 n507 vss sky130_fd_pr__res_high_po_1p41 l=3 mult=1
XR508 n509 n508 vss sky130_fd_pr__res_high_po_1p41 l=3 mult=1
XR509 n510 n509 vss sky130_fd_pr__res_high_po_1p41 l=3 mult=1
XR510 n511 n510 vss sky130_fd_pr__res_high_po_1p41 l=3 mult=1
XR511 n512 n511 vss sky130_fd_pr__res_high_po_1p41 l=3 mult=1
XR512 n513 n512 vss sky130_fd_pr__res_high_po_1p41 l=3 mult=1
XR513 n514 n513 vss sky130_fd_pr__res_high_po_1p41 l=3 mult=1
XR514 n515 n514 vss sky130_fd_pr__res_high_po_1p41 l=3 mult=1
XR515 n516 n515 vss sky130_fd_pr__res_high_po_1p41 l=3 mult=1
XR516 n517 n516 vss sky130_fd_pr__res_high_po_1p41 l=3 mult=1
XR517 n518 n517 vss sky130_fd_pr__res_high_po_1p41 l=3 mult=1
XR518 n519 n518 vss sky130_fd_pr__res_high_po_1p41 l=3 mult=1
XR519 top n519 vss sky130_fd_pr__res_high_po_1p41 l=3 mult=1
.ends
* adc_div: VOUT/2 divider, 6 x xhigh_po_5p73 (L = 16 um, 5.6 kohm), 10 pF MIM on vdiv
* (1.41 x 4 um units gave a 0.6 % ratio sigma; 16x the area for the same impedance)
.subckt adc_div vout vdiv vss
XD0 vout d1 vss sky130_fd_pr__res_xhigh_po_5p73 l=16 mult=1
XD1 d1 d2 vss sky130_fd_pr__res_xhigh_po_5p73 l=16 mult=1
XD2 d2 vdiv vss sky130_fd_pr__res_xhigh_po_5p73 l=16 mult=1
XD3 vdiv d4 vss sky130_fd_pr__res_xhigh_po_5p73 l=16 mult=1
XD4 d4 d5 vss sky130_fd_pr__res_xhigh_po_5p73 l=16 mult=1
XD5 d5 vss vss sky130_fd_pr__res_xhigh_po_5p73 l=16 mult=1
XCD vdiv vss sky130_fd_pr__cap_mim_m3_1 w=70 l=70 mf=1
.ends
