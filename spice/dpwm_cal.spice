* Calibrated DPWM fine stage (1.8 V, hd cells), generated by scripts/char_dpwm_cal.py.
* dpwm_cal: main line of 64 dlygate4sd3_1 + 64:1 mux tree (tap_sel = t5..t0) + NOR SR latch.
*   pwm_set sets the latch (HS on); pwm_rst enters the line; the selected tap resets it.
* tdc_line: replica line of 72 elements; the controller launches an edge and samples q1..q72
*   one clock later; the number of ones is N (elements per clock period).
.subckt dpwm_cal pwm_set pwm_rst t0 t1 t2 t3 t4 t5 hs_pwm vdd vss
XE0 pwm_rst vss vss vdd vdd m1 sky130_fd_sc_hd__dlygate4sd3_1
XE1 m1 vss vss vdd vdd m2 sky130_fd_sc_hd__dlygate4sd3_1
XE2 m2 vss vss vdd vdd m3 sky130_fd_sc_hd__dlygate4sd3_1
XE3 m3 vss vss vdd vdd m4 sky130_fd_sc_hd__dlygate4sd3_1
XE4 m4 vss vss vdd vdd m5 sky130_fd_sc_hd__dlygate4sd3_1
XE5 m5 vss vss vdd vdd m6 sky130_fd_sc_hd__dlygate4sd3_1
XE6 m6 vss vss vdd vdd m7 sky130_fd_sc_hd__dlygate4sd3_1
XE7 m7 vss vss vdd vdd m8 sky130_fd_sc_hd__dlygate4sd3_1
XE8 m8 vss vss vdd vdd m9 sky130_fd_sc_hd__dlygate4sd3_1
XE9 m9 vss vss vdd vdd m10 sky130_fd_sc_hd__dlygate4sd3_1
XE10 m10 vss vss vdd vdd m11 sky130_fd_sc_hd__dlygate4sd3_1
XE11 m11 vss vss vdd vdd m12 sky130_fd_sc_hd__dlygate4sd3_1
XE12 m12 vss vss vdd vdd m13 sky130_fd_sc_hd__dlygate4sd3_1
XE13 m13 vss vss vdd vdd m14 sky130_fd_sc_hd__dlygate4sd3_1
XE14 m14 vss vss vdd vdd m15 sky130_fd_sc_hd__dlygate4sd3_1
XE15 m15 vss vss vdd vdd m16 sky130_fd_sc_hd__dlygate4sd3_1
XE16 m16 vss vss vdd vdd m17 sky130_fd_sc_hd__dlygate4sd3_1
XE17 m17 vss vss vdd vdd m18 sky130_fd_sc_hd__dlygate4sd3_1
XE18 m18 vss vss vdd vdd m19 sky130_fd_sc_hd__dlygate4sd3_1
XE19 m19 vss vss vdd vdd m20 sky130_fd_sc_hd__dlygate4sd3_1
XE20 m20 vss vss vdd vdd m21 sky130_fd_sc_hd__dlygate4sd3_1
XE21 m21 vss vss vdd vdd m22 sky130_fd_sc_hd__dlygate4sd3_1
XE22 m22 vss vss vdd vdd m23 sky130_fd_sc_hd__dlygate4sd3_1
XE23 m23 vss vss vdd vdd m24 sky130_fd_sc_hd__dlygate4sd3_1
XE24 m24 vss vss vdd vdd m25 sky130_fd_sc_hd__dlygate4sd3_1
XE25 m25 vss vss vdd vdd m26 sky130_fd_sc_hd__dlygate4sd3_1
XE26 m26 vss vss vdd vdd m27 sky130_fd_sc_hd__dlygate4sd3_1
XE27 m27 vss vss vdd vdd m28 sky130_fd_sc_hd__dlygate4sd3_1
XE28 m28 vss vss vdd vdd m29 sky130_fd_sc_hd__dlygate4sd3_1
XE29 m29 vss vss vdd vdd m30 sky130_fd_sc_hd__dlygate4sd3_1
XE30 m30 vss vss vdd vdd m31 sky130_fd_sc_hd__dlygate4sd3_1
XE31 m31 vss vss vdd vdd m32 sky130_fd_sc_hd__dlygate4sd3_1
XE32 m32 vss vss vdd vdd m33 sky130_fd_sc_hd__dlygate4sd3_1
XE33 m33 vss vss vdd vdd m34 sky130_fd_sc_hd__dlygate4sd3_1
XE34 m34 vss vss vdd vdd m35 sky130_fd_sc_hd__dlygate4sd3_1
XE35 m35 vss vss vdd vdd m36 sky130_fd_sc_hd__dlygate4sd3_1
XE36 m36 vss vss vdd vdd m37 sky130_fd_sc_hd__dlygate4sd3_1
XE37 m37 vss vss vdd vdd m38 sky130_fd_sc_hd__dlygate4sd3_1
XE38 m38 vss vss vdd vdd m39 sky130_fd_sc_hd__dlygate4sd3_1
XE39 m39 vss vss vdd vdd m40 sky130_fd_sc_hd__dlygate4sd3_1
XE40 m40 vss vss vdd vdd m41 sky130_fd_sc_hd__dlygate4sd3_1
XE41 m41 vss vss vdd vdd m42 sky130_fd_sc_hd__dlygate4sd3_1
XE42 m42 vss vss vdd vdd m43 sky130_fd_sc_hd__dlygate4sd3_1
XE43 m43 vss vss vdd vdd m44 sky130_fd_sc_hd__dlygate4sd3_1
XE44 m44 vss vss vdd vdd m45 sky130_fd_sc_hd__dlygate4sd3_1
XE45 m45 vss vss vdd vdd m46 sky130_fd_sc_hd__dlygate4sd3_1
XE46 m46 vss vss vdd vdd m47 sky130_fd_sc_hd__dlygate4sd3_1
XE47 m47 vss vss vdd vdd m48 sky130_fd_sc_hd__dlygate4sd3_1
XE48 m48 vss vss vdd vdd m49 sky130_fd_sc_hd__dlygate4sd3_1
XE49 m49 vss vss vdd vdd m50 sky130_fd_sc_hd__dlygate4sd3_1
XE50 m50 vss vss vdd vdd m51 sky130_fd_sc_hd__dlygate4sd3_1
XE51 m51 vss vss vdd vdd m52 sky130_fd_sc_hd__dlygate4sd3_1
XE52 m52 vss vss vdd vdd m53 sky130_fd_sc_hd__dlygate4sd3_1
XE53 m53 vss vss vdd vdd m54 sky130_fd_sc_hd__dlygate4sd3_1
XE54 m54 vss vss vdd vdd m55 sky130_fd_sc_hd__dlygate4sd3_1
XE55 m55 vss vss vdd vdd m56 sky130_fd_sc_hd__dlygate4sd3_1
XE56 m56 vss vss vdd vdd m57 sky130_fd_sc_hd__dlygate4sd3_1
XE57 m57 vss vss vdd vdd m58 sky130_fd_sc_hd__dlygate4sd3_1
XE58 m58 vss vss vdd vdd m59 sky130_fd_sc_hd__dlygate4sd3_1
XE59 m59 vss vss vdd vdd m60 sky130_fd_sc_hd__dlygate4sd3_1
XE60 m60 vss vss vdd vdd m61 sky130_fd_sc_hd__dlygate4sd3_1
XE61 m61 vss vss vdd vdd m62 sky130_fd_sc_hd__dlygate4sd3_1
XE62 m62 vss vss vdd vdd m63 sky130_fd_sc_hd__dlygate4sd3_1
XE63 m63 vss vss vdd vdd m64 sky130_fd_sc_hd__dlygate4sd3_1
XM0_0 pwm_rst m1 t0 vss vss vdd vdd x0_0 sky130_fd_sc_hd__mux2_1
XM0_1 m2 m3 t0 vss vss vdd vdd x0_1 sky130_fd_sc_hd__mux2_1
XM0_2 m4 m5 t0 vss vss vdd vdd x0_2 sky130_fd_sc_hd__mux2_1
XM0_3 m6 m7 t0 vss vss vdd vdd x0_3 sky130_fd_sc_hd__mux2_1
XM0_4 m8 m9 t0 vss vss vdd vdd x0_4 sky130_fd_sc_hd__mux2_1
XM0_5 m10 m11 t0 vss vss vdd vdd x0_5 sky130_fd_sc_hd__mux2_1
XM0_6 m12 m13 t0 vss vss vdd vdd x0_6 sky130_fd_sc_hd__mux2_1
XM0_7 m14 m15 t0 vss vss vdd vdd x0_7 sky130_fd_sc_hd__mux2_1
XM0_8 m16 m17 t0 vss vss vdd vdd x0_8 sky130_fd_sc_hd__mux2_1
XM0_9 m18 m19 t0 vss vss vdd vdd x0_9 sky130_fd_sc_hd__mux2_1
XM0_10 m20 m21 t0 vss vss vdd vdd x0_10 sky130_fd_sc_hd__mux2_1
XM0_11 m22 m23 t0 vss vss vdd vdd x0_11 sky130_fd_sc_hd__mux2_1
XM0_12 m24 m25 t0 vss vss vdd vdd x0_12 sky130_fd_sc_hd__mux2_1
XM0_13 m26 m27 t0 vss vss vdd vdd x0_13 sky130_fd_sc_hd__mux2_1
XM0_14 m28 m29 t0 vss vss vdd vdd x0_14 sky130_fd_sc_hd__mux2_1
XM0_15 m30 m31 t0 vss vss vdd vdd x0_15 sky130_fd_sc_hd__mux2_1
XM0_16 m32 m33 t0 vss vss vdd vdd x0_16 sky130_fd_sc_hd__mux2_1
XM0_17 m34 m35 t0 vss vss vdd vdd x0_17 sky130_fd_sc_hd__mux2_1
XM0_18 m36 m37 t0 vss vss vdd vdd x0_18 sky130_fd_sc_hd__mux2_1
XM0_19 m38 m39 t0 vss vss vdd vdd x0_19 sky130_fd_sc_hd__mux2_1
XM0_20 m40 m41 t0 vss vss vdd vdd x0_20 sky130_fd_sc_hd__mux2_1
XM0_21 m42 m43 t0 vss vss vdd vdd x0_21 sky130_fd_sc_hd__mux2_1
XM0_22 m44 m45 t0 vss vss vdd vdd x0_22 sky130_fd_sc_hd__mux2_1
XM0_23 m46 m47 t0 vss vss vdd vdd x0_23 sky130_fd_sc_hd__mux2_1
XM0_24 m48 m49 t0 vss vss vdd vdd x0_24 sky130_fd_sc_hd__mux2_1
XM0_25 m50 m51 t0 vss vss vdd vdd x0_25 sky130_fd_sc_hd__mux2_1
XM0_26 m52 m53 t0 vss vss vdd vdd x0_26 sky130_fd_sc_hd__mux2_1
XM0_27 m54 m55 t0 vss vss vdd vdd x0_27 sky130_fd_sc_hd__mux2_1
XM0_28 m56 m57 t0 vss vss vdd vdd x0_28 sky130_fd_sc_hd__mux2_1
XM0_29 m58 m59 t0 vss vss vdd vdd x0_29 sky130_fd_sc_hd__mux2_1
XM0_30 m60 m61 t0 vss vss vdd vdd x0_30 sky130_fd_sc_hd__mux2_1
XM0_31 m62 m63 t0 vss vss vdd vdd x0_31 sky130_fd_sc_hd__mux2_1
XM1_0 x0_0 x0_1 t1 vss vss vdd vdd x1_0 sky130_fd_sc_hd__mux2_1
XM1_1 x0_2 x0_3 t1 vss vss vdd vdd x1_1 sky130_fd_sc_hd__mux2_1
XM1_2 x0_4 x0_5 t1 vss vss vdd vdd x1_2 sky130_fd_sc_hd__mux2_1
XM1_3 x0_6 x0_7 t1 vss vss vdd vdd x1_3 sky130_fd_sc_hd__mux2_1
XM1_4 x0_8 x0_9 t1 vss vss vdd vdd x1_4 sky130_fd_sc_hd__mux2_1
XM1_5 x0_10 x0_11 t1 vss vss vdd vdd x1_5 sky130_fd_sc_hd__mux2_1
XM1_6 x0_12 x0_13 t1 vss vss vdd vdd x1_6 sky130_fd_sc_hd__mux2_1
XM1_7 x0_14 x0_15 t1 vss vss vdd vdd x1_7 sky130_fd_sc_hd__mux2_1
XM1_8 x0_16 x0_17 t1 vss vss vdd vdd x1_8 sky130_fd_sc_hd__mux2_1
XM1_9 x0_18 x0_19 t1 vss vss vdd vdd x1_9 sky130_fd_sc_hd__mux2_1
XM1_10 x0_20 x0_21 t1 vss vss vdd vdd x1_10 sky130_fd_sc_hd__mux2_1
XM1_11 x0_22 x0_23 t1 vss vss vdd vdd x1_11 sky130_fd_sc_hd__mux2_1
XM1_12 x0_24 x0_25 t1 vss vss vdd vdd x1_12 sky130_fd_sc_hd__mux2_1
XM1_13 x0_26 x0_27 t1 vss vss vdd vdd x1_13 sky130_fd_sc_hd__mux2_1
XM1_14 x0_28 x0_29 t1 vss vss vdd vdd x1_14 sky130_fd_sc_hd__mux2_1
XM1_15 x0_30 x0_31 t1 vss vss vdd vdd x1_15 sky130_fd_sc_hd__mux2_1
XM2_0 x1_0 x1_1 t2 vss vss vdd vdd x2_0 sky130_fd_sc_hd__mux2_1
XM2_1 x1_2 x1_3 t2 vss vss vdd vdd x2_1 sky130_fd_sc_hd__mux2_1
XM2_2 x1_4 x1_5 t2 vss vss vdd vdd x2_2 sky130_fd_sc_hd__mux2_1
XM2_3 x1_6 x1_7 t2 vss vss vdd vdd x2_3 sky130_fd_sc_hd__mux2_1
XM2_4 x1_8 x1_9 t2 vss vss vdd vdd x2_4 sky130_fd_sc_hd__mux2_1
XM2_5 x1_10 x1_11 t2 vss vss vdd vdd x2_5 sky130_fd_sc_hd__mux2_1
XM2_6 x1_12 x1_13 t2 vss vss vdd vdd x2_6 sky130_fd_sc_hd__mux2_1
XM2_7 x1_14 x1_15 t2 vss vss vdd vdd x2_7 sky130_fd_sc_hd__mux2_1
XM3_0 x2_0 x2_1 t3 vss vss vdd vdd x3_0 sky130_fd_sc_hd__mux2_1
XM3_1 x2_2 x2_3 t3 vss vss vdd vdd x3_1 sky130_fd_sc_hd__mux2_1
XM3_2 x2_4 x2_5 t3 vss vss vdd vdd x3_2 sky130_fd_sc_hd__mux2_1
XM3_3 x2_6 x2_7 t3 vss vss vdd vdd x3_3 sky130_fd_sc_hd__mux2_1
XM4_0 x3_0 x3_1 t4 vss vss vdd vdd x4_0 sky130_fd_sc_hd__mux2_1
XM4_1 x3_2 x3_3 t4 vss vss vdd vdd x4_1 sky130_fd_sc_hd__mux2_1
XM5_0 x4_0 x4_1 t5 vss vss vdd vdd rst_d sky130_fd_sc_hd__mux2_1
XL1 rst_d qb vss vss vdd vdd hs_pwm sky130_fd_sc_hd__nor2_1
XL2 pwm_set hs_pwm vss vss vdd vdd qb sky130_fd_sc_hd__nor2_1
.ends
.subckt tdc_line launch q1 q2 q3 q4 q5 q6 q7 q8 q9 q10 q11 q12 q13 q14 q15 q16 q17 q18 q19 q20 q21 q22 q23 q24 q25 q26 q27 q28 q29 q30 q31 q32 q33 q34 q35 q36 q37 q38 q39 q40 q41 q42 q43 q44 q45 q46 q47 q48 q49 q50 q51 q52 q53 q54 q55 q56 q57 q58 q59 q60 q61 q62 q63 q64 q65 q66 q67 q68 q69 q70 q71 q72 vdd vss
XR0 launch vss vss vdd vdd q1 sky130_fd_sc_hd__dlygate4sd3_1
XR1 q1 vss vss vdd vdd q2 sky130_fd_sc_hd__dlygate4sd3_1
XR2 q2 vss vss vdd vdd q3 sky130_fd_sc_hd__dlygate4sd3_1
XR3 q3 vss vss vdd vdd q4 sky130_fd_sc_hd__dlygate4sd3_1
XR4 q4 vss vss vdd vdd q5 sky130_fd_sc_hd__dlygate4sd3_1
XR5 q5 vss vss vdd vdd q6 sky130_fd_sc_hd__dlygate4sd3_1
XR6 q6 vss vss vdd vdd q7 sky130_fd_sc_hd__dlygate4sd3_1
XR7 q7 vss vss vdd vdd q8 sky130_fd_sc_hd__dlygate4sd3_1
XR8 q8 vss vss vdd vdd q9 sky130_fd_sc_hd__dlygate4sd3_1
XR9 q9 vss vss vdd vdd q10 sky130_fd_sc_hd__dlygate4sd3_1
XR10 q10 vss vss vdd vdd q11 sky130_fd_sc_hd__dlygate4sd3_1
XR11 q11 vss vss vdd vdd q12 sky130_fd_sc_hd__dlygate4sd3_1
XR12 q12 vss vss vdd vdd q13 sky130_fd_sc_hd__dlygate4sd3_1
XR13 q13 vss vss vdd vdd q14 sky130_fd_sc_hd__dlygate4sd3_1
XR14 q14 vss vss vdd vdd q15 sky130_fd_sc_hd__dlygate4sd3_1
XR15 q15 vss vss vdd vdd q16 sky130_fd_sc_hd__dlygate4sd3_1
XR16 q16 vss vss vdd vdd q17 sky130_fd_sc_hd__dlygate4sd3_1
XR17 q17 vss vss vdd vdd q18 sky130_fd_sc_hd__dlygate4sd3_1
XR18 q18 vss vss vdd vdd q19 sky130_fd_sc_hd__dlygate4sd3_1
XR19 q19 vss vss vdd vdd q20 sky130_fd_sc_hd__dlygate4sd3_1
XR20 q20 vss vss vdd vdd q21 sky130_fd_sc_hd__dlygate4sd3_1
XR21 q21 vss vss vdd vdd q22 sky130_fd_sc_hd__dlygate4sd3_1
XR22 q22 vss vss vdd vdd q23 sky130_fd_sc_hd__dlygate4sd3_1
XR23 q23 vss vss vdd vdd q24 sky130_fd_sc_hd__dlygate4sd3_1
XR24 q24 vss vss vdd vdd q25 sky130_fd_sc_hd__dlygate4sd3_1
XR25 q25 vss vss vdd vdd q26 sky130_fd_sc_hd__dlygate4sd3_1
XR26 q26 vss vss vdd vdd q27 sky130_fd_sc_hd__dlygate4sd3_1
XR27 q27 vss vss vdd vdd q28 sky130_fd_sc_hd__dlygate4sd3_1
XR28 q28 vss vss vdd vdd q29 sky130_fd_sc_hd__dlygate4sd3_1
XR29 q29 vss vss vdd vdd q30 sky130_fd_sc_hd__dlygate4sd3_1
XR30 q30 vss vss vdd vdd q31 sky130_fd_sc_hd__dlygate4sd3_1
XR31 q31 vss vss vdd vdd q32 sky130_fd_sc_hd__dlygate4sd3_1
XR32 q32 vss vss vdd vdd q33 sky130_fd_sc_hd__dlygate4sd3_1
XR33 q33 vss vss vdd vdd q34 sky130_fd_sc_hd__dlygate4sd3_1
XR34 q34 vss vss vdd vdd q35 sky130_fd_sc_hd__dlygate4sd3_1
XR35 q35 vss vss vdd vdd q36 sky130_fd_sc_hd__dlygate4sd3_1
XR36 q36 vss vss vdd vdd q37 sky130_fd_sc_hd__dlygate4sd3_1
XR37 q37 vss vss vdd vdd q38 sky130_fd_sc_hd__dlygate4sd3_1
XR38 q38 vss vss vdd vdd q39 sky130_fd_sc_hd__dlygate4sd3_1
XR39 q39 vss vss vdd vdd q40 sky130_fd_sc_hd__dlygate4sd3_1
XR40 q40 vss vss vdd vdd q41 sky130_fd_sc_hd__dlygate4sd3_1
XR41 q41 vss vss vdd vdd q42 sky130_fd_sc_hd__dlygate4sd3_1
XR42 q42 vss vss vdd vdd q43 sky130_fd_sc_hd__dlygate4sd3_1
XR43 q43 vss vss vdd vdd q44 sky130_fd_sc_hd__dlygate4sd3_1
XR44 q44 vss vss vdd vdd q45 sky130_fd_sc_hd__dlygate4sd3_1
XR45 q45 vss vss vdd vdd q46 sky130_fd_sc_hd__dlygate4sd3_1
XR46 q46 vss vss vdd vdd q47 sky130_fd_sc_hd__dlygate4sd3_1
XR47 q47 vss vss vdd vdd q48 sky130_fd_sc_hd__dlygate4sd3_1
XR48 q48 vss vss vdd vdd q49 sky130_fd_sc_hd__dlygate4sd3_1
XR49 q49 vss vss vdd vdd q50 sky130_fd_sc_hd__dlygate4sd3_1
XR50 q50 vss vss vdd vdd q51 sky130_fd_sc_hd__dlygate4sd3_1
XR51 q51 vss vss vdd vdd q52 sky130_fd_sc_hd__dlygate4sd3_1
XR52 q52 vss vss vdd vdd q53 sky130_fd_sc_hd__dlygate4sd3_1
XR53 q53 vss vss vdd vdd q54 sky130_fd_sc_hd__dlygate4sd3_1
XR54 q54 vss vss vdd vdd q55 sky130_fd_sc_hd__dlygate4sd3_1
XR55 q55 vss vss vdd vdd q56 sky130_fd_sc_hd__dlygate4sd3_1
XR56 q56 vss vss vdd vdd q57 sky130_fd_sc_hd__dlygate4sd3_1
XR57 q57 vss vss vdd vdd q58 sky130_fd_sc_hd__dlygate4sd3_1
XR58 q58 vss vss vdd vdd q59 sky130_fd_sc_hd__dlygate4sd3_1
XR59 q59 vss vss vdd vdd q60 sky130_fd_sc_hd__dlygate4sd3_1
XR60 q60 vss vss vdd vdd q61 sky130_fd_sc_hd__dlygate4sd3_1
XR61 q61 vss vss vdd vdd q62 sky130_fd_sc_hd__dlygate4sd3_1
XR62 q62 vss vss vdd vdd q63 sky130_fd_sc_hd__dlygate4sd3_1
XR63 q63 vss vss vdd vdd q64 sky130_fd_sc_hd__dlygate4sd3_1
XR64 q64 vss vss vdd vdd q65 sky130_fd_sc_hd__dlygate4sd3_1
XR65 q65 vss vss vdd vdd q66 sky130_fd_sc_hd__dlygate4sd3_1
XR66 q66 vss vss vdd vdd q67 sky130_fd_sc_hd__dlygate4sd3_1
XR67 q67 vss vss vdd vdd q68 sky130_fd_sc_hd__dlygate4sd3_1
XR68 q68 vss vss vdd vdd q69 sky130_fd_sc_hd__dlygate4sd3_1
XR69 q69 vss vss vdd vdd q70 sky130_fd_sc_hd__dlygate4sd3_1
XR70 q70 vss vss vdd vdd q71 sky130_fd_sc_hd__dlygate4sd3_1
XR71 q71 vss vss vdd vdd q72 sky130_fd_sc_hd__dlygate4sd3_1
.ends
