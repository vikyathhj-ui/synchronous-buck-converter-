** sch_path: /foss/projects/synchronous-buck-converter-/xschem/adc_string.sch
.subckt adc_string top vss
*.PININFO top:B vss:B
XR0 vss n1 vss sky130_fd_pr__res_high_po_1p41 L=3 mult=1
XR1 n1 n2 vss sky130_fd_pr__res_high_po_1p41 L=3 mult=1
XR2 n2 n3 vss sky130_fd_pr__res_high_po_1p41 L=3 mult=1
XR3 n3 n4 vss sky130_fd_pr__res_high_po_1p41 L=3 mult=1
XR4 n4 n5 vss sky130_fd_pr__res_high_po_1p41 L=3 mult=1
XR5 n5 n6 vss sky130_fd_pr__res_high_po_1p41 L=3 mult=1
XR6 n6 n7 vss sky130_fd_pr__res_high_po_1p41 L=3 mult=1
XR7 n7 n8 vss sky130_fd_pr__res_high_po_1p41 L=3 mult=1
XR8 n8 n9 vss sky130_fd_pr__res_high_po_1p41 L=3 mult=1
XR9 n9 n10 vss sky130_fd_pr__res_high_po_1p41 L=3 mult=1
XR10 n10 n11 vss sky130_fd_pr__res_high_po_1p41 L=3 mult=1
XR11 n11 n12 vss sky130_fd_pr__res_high_po_1p41 L=3 mult=1
XR12 n12 n13 vss sky130_fd_pr__res_high_po_1p41 L=3 mult=1
XR13 n13 n14 vss sky130_fd_pr__res_high_po_1p41 L=3 mult=1
XR14 n14 n15 vss sky130_fd_pr__res_high_po_1p41 L=3 mult=1
XR15 n15 n16 vss sky130_fd_pr__res_high_po_1p41 L=3 mult=1
XR16 n16 n17 vss sky130_fd_pr__res_high_po_1p41 L=3 mult=1
XR17 n17 n18 vss sky130_fd_pr__res_high_po_1p41 L=3 mult=1
XR18 n18 n19 vss sky130_fd_pr__res_high_po_1p41 L=3 mult=1
XR19 n19 n20 vss sky130_fd_pr__res_high_po_1p41 L=3 mult=1
XR20 n20 n21 vss sky130_fd_pr__res_high_po_1p41 L=3 mult=1
XR21 n21 n22 vss sky130_fd_pr__res_high_po_1p41 L=3 mult=1
XR22 n22 n23 vss sky130_fd_pr__res_high_po_1p41 L=3 mult=1
XR23 n23 n24 vss sky130_fd_pr__res_high_po_1p41 L=3 mult=1
XR24 n24 n25 vss sky130_fd_pr__res_high_po_1p41 L=3 mult=1
XR25 n25 n26 vss sky130_fd_pr__res_high_po_1p41 L=3 mult=1
XR26 n26 n27 vss sky130_fd_pr__res_high_po_1p41 L=3 mult=1
XR27 n27 n28 vss sky130_fd_pr__res_high_po_1p41 L=3 mult=1
XR28 n28 n29 vss sky130_fd_pr__res_high_po_1p41 L=3 mult=1
XR29 n29 n30 vss sky130_fd_pr__res_high_po_1p41 L=3 mult=1
XR30 n30 n31 vss sky130_fd_pr__res_high_po_1p41 L=3 mult=1
XR31 n31 n32 vss sky130_fd_pr__res_high_po_1p41 L=3 mult=1
XR32 n32 n33 vss sky130_fd_pr__res_high_po_1p41 L=3 mult=1
XR33 n33 n34 vss sky130_fd_pr__res_high_po_1p41 L=3 mult=1
XR34 n34 n35 vss sky130_fd_pr__res_high_po_1p41 L=3 mult=1
XR35 n35 n36 vss sky130_fd_pr__res_high_po_1p41 L=3 mult=1
XR36 n36 n37 vss sky130_fd_pr__res_high_po_1p41 L=3 mult=1
XR37 n37 n38 vss sky130_fd_pr__res_high_po_1p41 L=3 mult=1
XR38 n38 n39 vss sky130_fd_pr__res_high_po_1p41 L=3 mult=1
XR39 n39 n40 vss sky130_fd_pr__res_high_po_1p41 L=3 mult=1
XR40 n40 n41 vss sky130_fd_pr__res_high_po_1p41 L=3 mult=1
XR41 n41 n42 vss sky130_fd_pr__res_high_po_1p41 L=3 mult=1
XR42 n42 n43 vss sky130_fd_pr__res_high_po_1p41 L=3 mult=1
XR43 n43 n44 vss sky130_fd_pr__res_high_po_1p41 L=3 mult=1
XR44 n44 n45 vss sky130_fd_pr__res_high_po_1p41 L=3 mult=1
XR45 n45 n46 vss sky130_fd_pr__res_high_po_1p41 L=3 mult=1
XR46 n46 n47 vss sky130_fd_pr__res_high_po_1p41 L=3 mult=1
XR47 n47 n48 vss sky130_fd_pr__res_high_po_1p41 L=3 mult=1
XR48 n48 n49 vss sky130_fd_pr__res_high_po_1p41 L=3 mult=1
XR49 n49 n50 vss sky130_fd_pr__res_high_po_1p41 L=3 mult=1
XR50 n50 n51 vss sky130_fd_pr__res_high_po_1p41 L=3 mult=1
XR51 n51 n52 vss sky130_fd_pr__res_high_po_1p41 L=3 mult=1
XR52 n52 n53 vss sky130_fd_pr__res_high_po_1p41 L=3 mult=1
XR53 n53 n54 vss sky130_fd_pr__res_high_po_1p41 L=3 mult=1
XR54 n54 n55 vss sky130_fd_pr__res_high_po_1p41 L=3 mult=1
XR55 n55 n56 vss sky130_fd_pr__res_high_po_1p41 L=3 mult=1
XR56 n56 n57 vss sky130_fd_pr__res_high_po_1p41 L=3 mult=1
XR57 n57 n58 vss sky130_fd_pr__res_high_po_1p41 L=3 mult=1
XR58 n58 n59 vss sky130_fd_pr__res_high_po_1p41 L=3 mult=1
XR59 n59 n60 vss sky130_fd_pr__res_high_po_1p41 L=3 mult=1
XR60 n60 n61 vss sky130_fd_pr__res_high_po_1p41 L=3 mult=1
XR61 n61 n62 vss sky130_fd_pr__res_high_po_1p41 L=3 mult=1
XR62 n62 n63 vss sky130_fd_pr__res_high_po_1p41 L=3 mult=1
XR63 n63 n64 vss sky130_fd_pr__res_high_po_1p41 L=3 mult=1
XR64 n64 n65 vss sky130_fd_pr__res_high_po_1p41 L=3 mult=1
XR65 n65 n66 vss sky130_fd_pr__res_high_po_1p41 L=3 mult=1
XR66 n66 n67 vss sky130_fd_pr__res_high_po_1p41 L=3 mult=1
XR67 n67 n68 vss sky130_fd_pr__res_high_po_1p41 L=3 mult=1
XR68 n68 n69 vss sky130_fd_pr__res_high_po_1p41 L=3 mult=1
XR69 n69 n70 vss sky130_fd_pr__res_high_po_1p41 L=3 mult=1
XR70 n70 n71 vss sky130_fd_pr__res_high_po_1p41 L=3 mult=1
XR71 n71 n72 vss sky130_fd_pr__res_high_po_1p41 L=3 mult=1
XR72 n72 n73 vss sky130_fd_pr__res_high_po_1p41 L=3 mult=1
XR73 n73 n74 vss sky130_fd_pr__res_high_po_1p41 L=3 mult=1
XR74 n74 n75 vss sky130_fd_pr__res_high_po_1p41 L=3 mult=1
XR75 n75 n76 vss sky130_fd_pr__res_high_po_1p41 L=3 mult=1
XR76 n76 n77 vss sky130_fd_pr__res_high_po_1p41 L=3 mult=1
XR77 n77 n78 vss sky130_fd_pr__res_high_po_1p41 L=3 mult=1
XR78 n78 n79 vss sky130_fd_pr__res_high_po_1p41 L=3 mult=1
XR79 n79 n80 vss sky130_fd_pr__res_high_po_1p41 L=3 mult=1
XR80 n80 n81 vss sky130_fd_pr__res_high_po_1p41 L=3 mult=1
XR81 n81 n82 vss sky130_fd_pr__res_high_po_1p41 L=3 mult=1
XR82 n82 n83 vss sky130_fd_pr__res_high_po_1p41 L=3 mult=1
XR83 n83 n84 vss sky130_fd_pr__res_high_po_1p41 L=3 mult=1
XR84 n84 n85 vss sky130_fd_pr__res_high_po_1p41 L=3 mult=1
XR85 n85 n86 vss sky130_fd_pr__res_high_po_1p41 L=3 mult=1
XR86 n86 n87 vss sky130_fd_pr__res_high_po_1p41 L=3 mult=1
XR87 n87 n88 vss sky130_fd_pr__res_high_po_1p41 L=3 mult=1
XR88 n88 n89 vss sky130_fd_pr__res_high_po_1p41 L=3 mult=1
XR89 n89 n90 vss sky130_fd_pr__res_high_po_1p41 L=3 mult=1
XR90 n90 n91 vss sky130_fd_pr__res_high_po_1p41 L=3 mult=1
XR91 n91 n92 vss sky130_fd_pr__res_high_po_1p41 L=3 mult=1
XR92 n92 n93 vss sky130_fd_pr__res_high_po_1p41 L=3 mult=1
XR93 n93 n94 vss sky130_fd_pr__res_high_po_1p41 L=3 mult=1
XR94 n94 n95 vss sky130_fd_pr__res_high_po_1p41 L=3 mult=1
XR95 n95 n96 vss sky130_fd_pr__res_high_po_1p41 L=3 mult=1
XR96 n96 n97 vss sky130_fd_pr__res_high_po_1p41 L=3 mult=1
XR97 n97 n98 vss sky130_fd_pr__res_high_po_1p41 L=3 mult=1
XR98 n98 n99 vss sky130_fd_pr__res_high_po_1p41 L=3 mult=1
XR99 n99 n100 vss sky130_fd_pr__res_high_po_1p41 L=3 mult=1
XR100 n100 n101 vss sky130_fd_pr__res_high_po_1p41 L=3 mult=1
XR101 n101 n102 vss sky130_fd_pr__res_high_po_1p41 L=3 mult=1
XR102 n102 n103 vss sky130_fd_pr__res_high_po_1p41 L=3 mult=1
XR103 n103 n104 vss sky130_fd_pr__res_high_po_1p41 L=3 mult=1
XR104 n104 n105 vss sky130_fd_pr__res_high_po_1p41 L=3 mult=1
XR105 n105 n106 vss sky130_fd_pr__res_high_po_1p41 L=3 mult=1
XR106 n106 n107 vss sky130_fd_pr__res_high_po_1p41 L=3 mult=1
XR107 n107 n108 vss sky130_fd_pr__res_high_po_1p41 L=3 mult=1
XR108 n108 n109 vss sky130_fd_pr__res_high_po_1p41 L=3 mult=1
XR109 n109 n110 vss sky130_fd_pr__res_high_po_1p41 L=3 mult=1
XR110 n110 n111 vss sky130_fd_pr__res_high_po_1p41 L=3 mult=1
XR111 n111 n112 vss sky130_fd_pr__res_high_po_1p41 L=3 mult=1
XR112 n112 n113 vss sky130_fd_pr__res_high_po_1p41 L=3 mult=1
XR113 n113 n114 vss sky130_fd_pr__res_high_po_1p41 L=3 mult=1
XR114 n114 n115 vss sky130_fd_pr__res_high_po_1p41 L=3 mult=1
XR115 n115 n116 vss sky130_fd_pr__res_high_po_1p41 L=3 mult=1
XR116 n116 n117 vss sky130_fd_pr__res_high_po_1p41 L=3 mult=1
XR117 n117 n118 vss sky130_fd_pr__res_high_po_1p41 L=3 mult=1
XR118 n118 n119 vss sky130_fd_pr__res_high_po_1p41 L=3 mult=1
XR119 n119 n120 vss sky130_fd_pr__res_high_po_1p41 L=3 mult=1
XR120 n120 n121 vss sky130_fd_pr__res_high_po_1p41 L=3 mult=1
XR121 n121 n122 vss sky130_fd_pr__res_high_po_1p41 L=3 mult=1
XR122 n122 n123 vss sky130_fd_pr__res_high_po_1p41 L=3 mult=1
XR123 n123 n124 vss sky130_fd_pr__res_high_po_1p41 L=3 mult=1
XR124 n124 n125 vss sky130_fd_pr__res_high_po_1p41 L=3 mult=1
XR125 n125 n126 vss sky130_fd_pr__res_high_po_1p41 L=3 mult=1
XR126 n126 n127 vss sky130_fd_pr__res_high_po_1p41 L=3 mult=1
XR127 n127 n128 vss sky130_fd_pr__res_high_po_1p41 L=3 mult=1
XR128 n128 n129 vss sky130_fd_pr__res_high_po_1p41 L=3 mult=1
XR129 n129 n130 vss sky130_fd_pr__res_high_po_1p41 L=3 mult=1
XR130 n130 n131 vss sky130_fd_pr__res_high_po_1p41 L=3 mult=1
XR131 n131 n132 vss sky130_fd_pr__res_high_po_1p41 L=3 mult=1
XR132 n132 n133 vss sky130_fd_pr__res_high_po_1p41 L=3 mult=1
XR133 n133 n134 vss sky130_fd_pr__res_high_po_1p41 L=3 mult=1
XR134 n134 n135 vss sky130_fd_pr__res_high_po_1p41 L=3 mult=1
XR135 n135 n136 vss sky130_fd_pr__res_high_po_1p41 L=3 mult=1
XR136 n136 n137 vss sky130_fd_pr__res_high_po_1p41 L=3 mult=1
XR137 n137 n138 vss sky130_fd_pr__res_high_po_1p41 L=3 mult=1
XR138 n138 n139 vss sky130_fd_pr__res_high_po_1p41 L=3 mult=1
XR139 n139 n140 vss sky130_fd_pr__res_high_po_1p41 L=3 mult=1
XR140 n140 n141 vss sky130_fd_pr__res_high_po_1p41 L=3 mult=1
XR141 n141 n142 vss sky130_fd_pr__res_high_po_1p41 L=3 mult=1
XR142 n142 n143 vss sky130_fd_pr__res_high_po_1p41 L=3 mult=1
XR143 n143 n144 vss sky130_fd_pr__res_high_po_1p41 L=3 mult=1
XR144 n144 n145 vss sky130_fd_pr__res_high_po_1p41 L=3 mult=1
XR145 n145 n146 vss sky130_fd_pr__res_high_po_1p41 L=3 mult=1
XR146 n146 n147 vss sky130_fd_pr__res_high_po_1p41 L=3 mult=1
XR147 n147 n148 vss sky130_fd_pr__res_high_po_1p41 L=3 mult=1
XR148 n148 n149 vss sky130_fd_pr__res_high_po_1p41 L=3 mult=1
XR149 n149 n150 vss sky130_fd_pr__res_high_po_1p41 L=3 mult=1
XR150 n150 n151 vss sky130_fd_pr__res_high_po_1p41 L=3 mult=1
XR151 n151 n152 vss sky130_fd_pr__res_high_po_1p41 L=3 mult=1
XR152 n152 n153 vss sky130_fd_pr__res_high_po_1p41 L=3 mult=1
XR153 n153 n154 vss sky130_fd_pr__res_high_po_1p41 L=3 mult=1
XR154 n154 n155 vss sky130_fd_pr__res_high_po_1p41 L=3 mult=1
XR155 n155 n156 vss sky130_fd_pr__res_high_po_1p41 L=3 mult=1
XR156 n156 n157 vss sky130_fd_pr__res_high_po_1p41 L=3 mult=1
XR157 n157 n158 vss sky130_fd_pr__res_high_po_1p41 L=3 mult=1
XR158 n158 n159 vss sky130_fd_pr__res_high_po_1p41 L=3 mult=1
XR159 n159 n160 vss sky130_fd_pr__res_high_po_1p41 L=3 mult=1
XR160 n160 n161 vss sky130_fd_pr__res_high_po_1p41 L=3 mult=1
XR161 n161 n162 vss sky130_fd_pr__res_high_po_1p41 L=3 mult=1
XR162 n162 n163 vss sky130_fd_pr__res_high_po_1p41 L=3 mult=1
XR163 n163 n164 vss sky130_fd_pr__res_high_po_1p41 L=3 mult=1
XR164 n164 n165 vss sky130_fd_pr__res_high_po_1p41 L=3 mult=1
XR165 n165 n166 vss sky130_fd_pr__res_high_po_1p41 L=3 mult=1
XR166 n166 n167 vss sky130_fd_pr__res_high_po_1p41 L=3 mult=1
XR167 n167 n168 vss sky130_fd_pr__res_high_po_1p41 L=3 mult=1
XR168 n168 n169 vss sky130_fd_pr__res_high_po_1p41 L=3 mult=1
XR169 n169 n170 vss sky130_fd_pr__res_high_po_1p41 L=3 mult=1
XR170 n170 n171 vss sky130_fd_pr__res_high_po_1p41 L=3 mult=1
XR171 n171 n172 vss sky130_fd_pr__res_high_po_1p41 L=3 mult=1
XR172 n172 n173 vss sky130_fd_pr__res_high_po_1p41 L=3 mult=1
XR173 n173 n174 vss sky130_fd_pr__res_high_po_1p41 L=3 mult=1
XR174 n174 n175 vss sky130_fd_pr__res_high_po_1p41 L=3 mult=1
XR175 n175 n176 vss sky130_fd_pr__res_high_po_1p41 L=3 mult=1
XR176 n176 n177 vss sky130_fd_pr__res_high_po_1p41 L=3 mult=1
XR177 n177 n178 vss sky130_fd_pr__res_high_po_1p41 L=3 mult=1
XR178 n178 n179 vss sky130_fd_pr__res_high_po_1p41 L=3 mult=1
XR179 n179 n180 vss sky130_fd_pr__res_high_po_1p41 L=3 mult=1
XR180 n180 n181 vss sky130_fd_pr__res_high_po_1p41 L=3 mult=1
XR181 n181 n182 vss sky130_fd_pr__res_high_po_1p41 L=3 mult=1
XR182 n182 n183 vss sky130_fd_pr__res_high_po_1p41 L=3 mult=1
XR183 n183 n184 vss sky130_fd_pr__res_high_po_1p41 L=3 mult=1
XR184 n184 n185 vss sky130_fd_pr__res_high_po_1p41 L=3 mult=1
XR185 n185 n186 vss sky130_fd_pr__res_high_po_1p41 L=3 mult=1
XR186 n186 n187 vss sky130_fd_pr__res_high_po_1p41 L=3 mult=1
XR187 n187 n188 vss sky130_fd_pr__res_high_po_1p41 L=3 mult=1
XR188 n188 n189 vss sky130_fd_pr__res_high_po_1p41 L=3 mult=1
XR189 n189 n190 vss sky130_fd_pr__res_high_po_1p41 L=3 mult=1
XR190 n190 n191 vss sky130_fd_pr__res_high_po_1p41 L=3 mult=1
XR191 n191 n192 vss sky130_fd_pr__res_high_po_1p41 L=3 mult=1
XR192 n192 n193 vss sky130_fd_pr__res_high_po_1p41 L=3 mult=1
XR193 n193 n194 vss sky130_fd_pr__res_high_po_1p41 L=3 mult=1
XR194 n194 n195 vss sky130_fd_pr__res_high_po_1p41 L=3 mult=1
XR195 n195 n196 vss sky130_fd_pr__res_high_po_1p41 L=3 mult=1
XR196 n196 n197 vss sky130_fd_pr__res_high_po_1p41 L=3 mult=1
XR197 n197 n198 vss sky130_fd_pr__res_high_po_1p41 L=3 mult=1
XR198 n198 n199 vss sky130_fd_pr__res_high_po_1p41 L=3 mult=1
XR199 n199 n200 vss sky130_fd_pr__res_high_po_1p41 L=3 mult=1
XR200 n200 n201 vss sky130_fd_pr__res_high_po_1p41 L=3 mult=1
XR201 n201 n202 vss sky130_fd_pr__res_high_po_1p41 L=3 mult=1
XR202 n202 n203 vss sky130_fd_pr__res_high_po_1p41 L=3 mult=1
XR203 n203 n204 vss sky130_fd_pr__res_high_po_1p41 L=3 mult=1
XR204 n204 n205 vss sky130_fd_pr__res_high_po_1p41 L=3 mult=1
XR205 n205 n206 vss sky130_fd_pr__res_high_po_1p41 L=3 mult=1
XR206 n206 n207 vss sky130_fd_pr__res_high_po_1p41 L=3 mult=1
XR207 n207 n208 vss sky130_fd_pr__res_high_po_1p41 L=3 mult=1
XR208 n208 n209 vss sky130_fd_pr__res_high_po_1p41 L=3 mult=1
XR209 n209 n210 vss sky130_fd_pr__res_high_po_1p41 L=3 mult=1
XR210 n210 n211 vss sky130_fd_pr__res_high_po_1p41 L=3 mult=1
XR211 n211 n212 vss sky130_fd_pr__res_high_po_1p41 L=3 mult=1
XR212 n212 n213 vss sky130_fd_pr__res_high_po_1p41 L=3 mult=1
XR213 n213 n214 vss sky130_fd_pr__res_high_po_1p41 L=3 mult=1
XR214 n214 n215 vss sky130_fd_pr__res_high_po_1p41 L=3 mult=1
XR215 n215 n216 vss sky130_fd_pr__res_high_po_1p41 L=3 mult=1
XR216 n216 n217 vss sky130_fd_pr__res_high_po_1p41 L=3 mult=1
XR217 n217 n218 vss sky130_fd_pr__res_high_po_1p41 L=3 mult=1
XR218 n218 n219 vss sky130_fd_pr__res_high_po_1p41 L=3 mult=1
XR219 n219 n220 vss sky130_fd_pr__res_high_po_1p41 L=3 mult=1
XR220 n220 n221 vss sky130_fd_pr__res_high_po_1p41 L=3 mult=1
XR221 n221 n222 vss sky130_fd_pr__res_high_po_1p41 L=3 mult=1
XR222 n222 n223 vss sky130_fd_pr__res_high_po_1p41 L=3 mult=1
XR223 n223 n224 vss sky130_fd_pr__res_high_po_1p41 L=3 mult=1
XR224 n224 n225 vss sky130_fd_pr__res_high_po_1p41 L=3 mult=1
XR225 n225 n226 vss sky130_fd_pr__res_high_po_1p41 L=3 mult=1
XR226 n226 n227 vss sky130_fd_pr__res_high_po_1p41 L=3 mult=1
XR227 n227 n228 vss sky130_fd_pr__res_high_po_1p41 L=3 mult=1
XR228 n228 n229 vss sky130_fd_pr__res_high_po_1p41 L=3 mult=1
XR229 n229 n230 vss sky130_fd_pr__res_high_po_1p41 L=3 mult=1
XR230 n230 n231 vss sky130_fd_pr__res_high_po_1p41 L=3 mult=1
XR231 n231 n232 vss sky130_fd_pr__res_high_po_1p41 L=3 mult=1
XR232 n232 n233 vss sky130_fd_pr__res_high_po_1p41 L=3 mult=1
XR233 n233 n234 vss sky130_fd_pr__res_high_po_1p41 L=3 mult=1
XR234 n234 n235 vss sky130_fd_pr__res_high_po_1p41 L=3 mult=1
XR235 n235 n236 vss sky130_fd_pr__res_high_po_1p41 L=3 mult=1
XR236 n236 n237 vss sky130_fd_pr__res_high_po_1p41 L=3 mult=1
XR237 n237 n238 vss sky130_fd_pr__res_high_po_1p41 L=3 mult=1
XR238 n238 n239 vss sky130_fd_pr__res_high_po_1p41 L=3 mult=1
XR239 n239 n240 vss sky130_fd_pr__res_high_po_1p41 L=3 mult=1
XR240 n240 n241 vss sky130_fd_pr__res_high_po_1p41 L=3 mult=1
XR241 n241 n242 vss sky130_fd_pr__res_high_po_1p41 L=3 mult=1
XR242 n242 n243 vss sky130_fd_pr__res_high_po_1p41 L=3 mult=1
XR243 n243 n244 vss sky130_fd_pr__res_high_po_1p41 L=3 mult=1
XR244 n244 n245 vss sky130_fd_pr__res_high_po_1p41 L=3 mult=1
XR245 n245 n246 vss sky130_fd_pr__res_high_po_1p41 L=3 mult=1
XR246 n246 n247 vss sky130_fd_pr__res_high_po_1p41 L=3 mult=1
XR247 n247 n248 vss sky130_fd_pr__res_high_po_1p41 L=3 mult=1
XR248 n248 n249 vss sky130_fd_pr__res_high_po_1p41 L=3 mult=1
XR249 n249 n250 vss sky130_fd_pr__res_high_po_1p41 L=3 mult=1
XR250 n250 n251 vss sky130_fd_pr__res_high_po_1p41 L=3 mult=1
XR251 n251 n252 vss sky130_fd_pr__res_high_po_1p41 L=3 mult=1
XR252 n252 n253 vss sky130_fd_pr__res_high_po_1p41 L=3 mult=1
XR253 n253 n254 vss sky130_fd_pr__res_high_po_1p41 L=3 mult=1
XR254 n254 n255 vss sky130_fd_pr__res_high_po_1p41 L=3 mult=1
XR255 n255 n256 vss sky130_fd_pr__res_high_po_1p41 L=3 mult=1
XR256 n256 n257 vss sky130_fd_pr__res_high_po_1p41 L=3 mult=1
XR257 n257 n258 vss sky130_fd_pr__res_high_po_1p41 L=3 mult=1
XR258 n258 n259 vss sky130_fd_pr__res_high_po_1p41 L=3 mult=1
XR259 n259 n260 vss sky130_fd_pr__res_high_po_1p41 L=3 mult=1
XR260 n260 n261 vss sky130_fd_pr__res_high_po_1p41 L=3 mult=1
XR261 n261 n262 vss sky130_fd_pr__res_high_po_1p41 L=3 mult=1
XR262 n262 n263 vss sky130_fd_pr__res_high_po_1p41 L=3 mult=1
XR263 n263 n264 vss sky130_fd_pr__res_high_po_1p41 L=3 mult=1
XR264 n264 n265 vss sky130_fd_pr__res_high_po_1p41 L=3 mult=1
XR265 n265 n266 vss sky130_fd_pr__res_high_po_1p41 L=3 mult=1
XR266 n266 n267 vss sky130_fd_pr__res_high_po_1p41 L=3 mult=1
XR267 n267 n268 vss sky130_fd_pr__res_high_po_1p41 L=3 mult=1
XR268 n268 n269 vss sky130_fd_pr__res_high_po_1p41 L=3 mult=1
XR269 n269 n270 vss sky130_fd_pr__res_high_po_1p41 L=3 mult=1
XR270 n270 n271 vss sky130_fd_pr__res_high_po_1p41 L=3 mult=1
XR271 n271 n272 vss sky130_fd_pr__res_high_po_1p41 L=3 mult=1
XR272 n272 n273 vss sky130_fd_pr__res_high_po_1p41 L=3 mult=1
XR273 n273 n274 vss sky130_fd_pr__res_high_po_1p41 L=3 mult=1
XR274 n274 n275 vss sky130_fd_pr__res_high_po_1p41 L=3 mult=1
XR275 n275 n276 vss sky130_fd_pr__res_high_po_1p41 L=3 mult=1
XR276 n276 n277 vss sky130_fd_pr__res_high_po_1p41 L=3 mult=1
XR277 n277 n278 vss sky130_fd_pr__res_high_po_1p41 L=3 mult=1
XR278 n278 n279 vss sky130_fd_pr__res_high_po_1p41 L=3 mult=1
XR279 n279 n280 vss sky130_fd_pr__res_high_po_1p41 L=3 mult=1
XR280 n280 n281 vss sky130_fd_pr__res_high_po_1p41 L=3 mult=1
XR281 n281 n282 vss sky130_fd_pr__res_high_po_1p41 L=3 mult=1
XR282 n282 n283 vss sky130_fd_pr__res_high_po_1p41 L=3 mult=1
XR283 n283 n284 vss sky130_fd_pr__res_high_po_1p41 L=3 mult=1
XR284 n284 n285 vss sky130_fd_pr__res_high_po_1p41 L=3 mult=1
XR285 n285 n286 vss sky130_fd_pr__res_high_po_1p41 L=3 mult=1
XR286 n286 n287 vss sky130_fd_pr__res_high_po_1p41 L=3 mult=1
XR287 n287 n288 vss sky130_fd_pr__res_high_po_1p41 L=3 mult=1
XR288 n288 n289 vss sky130_fd_pr__res_high_po_1p41 L=3 mult=1
XR289 n289 n290 vss sky130_fd_pr__res_high_po_1p41 L=3 mult=1
XR290 n290 n291 vss sky130_fd_pr__res_high_po_1p41 L=3 mult=1
XR291 n291 n292 vss sky130_fd_pr__res_high_po_1p41 L=3 mult=1
XR292 n292 n293 vss sky130_fd_pr__res_high_po_1p41 L=3 mult=1
XR293 n293 n294 vss sky130_fd_pr__res_high_po_1p41 L=3 mult=1
XR294 n294 n295 vss sky130_fd_pr__res_high_po_1p41 L=3 mult=1
XR295 n295 n296 vss sky130_fd_pr__res_high_po_1p41 L=3 mult=1
XR296 n296 n297 vss sky130_fd_pr__res_high_po_1p41 L=3 mult=1
XR297 n297 n298 vss sky130_fd_pr__res_high_po_1p41 L=3 mult=1
XR298 n298 n299 vss sky130_fd_pr__res_high_po_1p41 L=3 mult=1
XR299 n299 n300 vss sky130_fd_pr__res_high_po_1p41 L=3 mult=1
XR300 n300 n301 vss sky130_fd_pr__res_high_po_1p41 L=3 mult=1
XR301 n301 n302 vss sky130_fd_pr__res_high_po_1p41 L=3 mult=1
XR302 n302 n303 vss sky130_fd_pr__res_high_po_1p41 L=3 mult=1
XR303 n303 n304 vss sky130_fd_pr__res_high_po_1p41 L=3 mult=1
XR304 n304 n305 vss sky130_fd_pr__res_high_po_1p41 L=3 mult=1
XR305 n305 n306 vss sky130_fd_pr__res_high_po_1p41 L=3 mult=1
XR306 n306 n307 vss sky130_fd_pr__res_high_po_1p41 L=3 mult=1
XR307 n307 n308 vss sky130_fd_pr__res_high_po_1p41 L=3 mult=1
XR308 n308 n309 vss sky130_fd_pr__res_high_po_1p41 L=3 mult=1
XR309 n309 n310 vss sky130_fd_pr__res_high_po_1p41 L=3 mult=1
XR310 n310 n311 vss sky130_fd_pr__res_high_po_1p41 L=3 mult=1
XR311 n311 n312 vss sky130_fd_pr__res_high_po_1p41 L=3 mult=1
XR312 n312 n313 vss sky130_fd_pr__res_high_po_1p41 L=3 mult=1
XR313 n313 n314 vss sky130_fd_pr__res_high_po_1p41 L=3 mult=1
XR314 n314 n315 vss sky130_fd_pr__res_high_po_1p41 L=3 mult=1
XR315 n315 n316 vss sky130_fd_pr__res_high_po_1p41 L=3 mult=1
XR316 n316 n317 vss sky130_fd_pr__res_high_po_1p41 L=3 mult=1
XR317 n317 n318 vss sky130_fd_pr__res_high_po_1p41 L=3 mult=1
XR318 n318 n319 vss sky130_fd_pr__res_high_po_1p41 L=3 mult=1
XR319 n319 n320 vss sky130_fd_pr__res_high_po_1p41 L=3 mult=1
XR320 n320 n321 vss sky130_fd_pr__res_high_po_1p41 L=3 mult=1
XR321 n321 n322 vss sky130_fd_pr__res_high_po_1p41 L=3 mult=1
XR322 n322 n323 vss sky130_fd_pr__res_high_po_1p41 L=3 mult=1
XR323 n323 n324 vss sky130_fd_pr__res_high_po_1p41 L=3 mult=1
XR324 n324 n325 vss sky130_fd_pr__res_high_po_1p41 L=3 mult=1
XR325 n325 n326 vss sky130_fd_pr__res_high_po_1p41 L=3 mult=1
XR326 n326 n327 vss sky130_fd_pr__res_high_po_1p41 L=3 mult=1
XR327 n327 n328 vss sky130_fd_pr__res_high_po_1p41 L=3 mult=1
XR328 n328 n329 vss sky130_fd_pr__res_high_po_1p41 L=3 mult=1
XR329 n329 n330 vss sky130_fd_pr__res_high_po_1p41 L=3 mult=1
XR330 n330 n331 vss sky130_fd_pr__res_high_po_1p41 L=3 mult=1
XR331 n331 n332 vss sky130_fd_pr__res_high_po_1p41 L=3 mult=1
XR332 n332 n333 vss sky130_fd_pr__res_high_po_1p41 L=3 mult=1
XR333 n333 n334 vss sky130_fd_pr__res_high_po_1p41 L=3 mult=1
XR334 n334 n335 vss sky130_fd_pr__res_high_po_1p41 L=3 mult=1
XR335 n335 n336 vss sky130_fd_pr__res_high_po_1p41 L=3 mult=1
XR336 n336 n337 vss sky130_fd_pr__res_high_po_1p41 L=3 mult=1
XR337 n337 n338 vss sky130_fd_pr__res_high_po_1p41 L=3 mult=1
XR338 n338 n339 vss sky130_fd_pr__res_high_po_1p41 L=3 mult=1
XR339 n339 n340 vss sky130_fd_pr__res_high_po_1p41 L=3 mult=1
XR340 n340 n341 vss sky130_fd_pr__res_high_po_1p41 L=3 mult=1
XR341 n341 n342 vss sky130_fd_pr__res_high_po_1p41 L=3 mult=1
XR342 n342 n343 vss sky130_fd_pr__res_high_po_1p41 L=3 mult=1
XR343 n343 n344 vss sky130_fd_pr__res_high_po_1p41 L=3 mult=1
XR344 n344 n345 vss sky130_fd_pr__res_high_po_1p41 L=3 mult=1
XR345 n345 n346 vss sky130_fd_pr__res_high_po_1p41 L=3 mult=1
XR346 n346 n347 vss sky130_fd_pr__res_high_po_1p41 L=3 mult=1
XR347 n347 n348 vss sky130_fd_pr__res_high_po_1p41 L=3 mult=1
XR348 n348 n349 vss sky130_fd_pr__res_high_po_1p41 L=3 mult=1
XR349 n349 n350 vss sky130_fd_pr__res_high_po_1p41 L=3 mult=1
XR350 n350 n351 vss sky130_fd_pr__res_high_po_1p41 L=3 mult=1
XR351 n351 n352 vss sky130_fd_pr__res_high_po_1p41 L=3 mult=1
XR352 n352 n353 vss sky130_fd_pr__res_high_po_1p41 L=3 mult=1
XR353 n353 n354 vss sky130_fd_pr__res_high_po_1p41 L=3 mult=1
XR354 n354 n355 vss sky130_fd_pr__res_high_po_1p41 L=3 mult=1
XR355 n355 n356 vss sky130_fd_pr__res_high_po_1p41 L=3 mult=1
XR356 n356 n357 vss sky130_fd_pr__res_high_po_1p41 L=3 mult=1
XR357 n357 n358 vss sky130_fd_pr__res_high_po_1p41 L=3 mult=1
XR358 n358 n359 vss sky130_fd_pr__res_high_po_1p41 L=3 mult=1
XR359 n359 n360 vss sky130_fd_pr__res_high_po_1p41 L=3 mult=1
XR360 n360 n361 vss sky130_fd_pr__res_high_po_1p41 L=3 mult=1
XR361 n361 n362 vss sky130_fd_pr__res_high_po_1p41 L=3 mult=1
XR362 n362 n363 vss sky130_fd_pr__res_high_po_1p41 L=3 mult=1
XR363 n363 n364 vss sky130_fd_pr__res_high_po_1p41 L=3 mult=1
XR364 n364 n365 vss sky130_fd_pr__res_high_po_1p41 L=3 mult=1
XR365 n365 n366 vss sky130_fd_pr__res_high_po_1p41 L=3 mult=1
XR366 n366 n367 vss sky130_fd_pr__res_high_po_1p41 L=3 mult=1
XR367 n367 n368 vss sky130_fd_pr__res_high_po_1p41 L=3 mult=1
XR368 n368 n369 vss sky130_fd_pr__res_high_po_1p41 L=3 mult=1
XR369 n369 n370 vss sky130_fd_pr__res_high_po_1p41 L=3 mult=1
XR370 n370 n371 vss sky130_fd_pr__res_high_po_1p41 L=3 mult=1
XR371 n371 n372 vss sky130_fd_pr__res_high_po_1p41 L=3 mult=1
XR372 n372 n373 vss sky130_fd_pr__res_high_po_1p41 L=3 mult=1
XR373 n373 n374 vss sky130_fd_pr__res_high_po_1p41 L=3 mult=1
XR374 n374 n375 vss sky130_fd_pr__res_high_po_1p41 L=3 mult=1
XR375 n375 n376 vss sky130_fd_pr__res_high_po_1p41 L=3 mult=1
XR376 n376 n377 vss sky130_fd_pr__res_high_po_1p41 L=3 mult=1
XR377 n377 n378 vss sky130_fd_pr__res_high_po_1p41 L=3 mult=1
XR378 n378 n379 vss sky130_fd_pr__res_high_po_1p41 L=3 mult=1
XR379 n379 n380 vss sky130_fd_pr__res_high_po_1p41 L=3 mult=1
XR380 n380 n381 vss sky130_fd_pr__res_high_po_1p41 L=3 mult=1
XR381 n381 n382 vss sky130_fd_pr__res_high_po_1p41 L=3 mult=1
XR382 n382 n383 vss sky130_fd_pr__res_high_po_1p41 L=3 mult=1
XR383 n383 n384 vss sky130_fd_pr__res_high_po_1p41 L=3 mult=1
XR384 n384 n385 vss sky130_fd_pr__res_high_po_1p41 L=3 mult=1
XR385 n385 n386 vss sky130_fd_pr__res_high_po_1p41 L=3 mult=1
XR386 n386 n387 vss sky130_fd_pr__res_high_po_1p41 L=3 mult=1
XR387 n387 n388 vss sky130_fd_pr__res_high_po_1p41 L=3 mult=1
XR388 n388 n389 vss sky130_fd_pr__res_high_po_1p41 L=3 mult=1
XR389 n389 n390 vss sky130_fd_pr__res_high_po_1p41 L=3 mult=1
XR390 n390 n391 vss sky130_fd_pr__res_high_po_1p41 L=3 mult=1
XR391 n391 n392 vss sky130_fd_pr__res_high_po_1p41 L=3 mult=1
XR392 n392 n393 vss sky130_fd_pr__res_high_po_1p41 L=3 mult=1
XR393 n393 n394 vss sky130_fd_pr__res_high_po_1p41 L=3 mult=1
XR394 n394 n395 vss sky130_fd_pr__res_high_po_1p41 L=3 mult=1
XR395 n395 n396 vss sky130_fd_pr__res_high_po_1p41 L=3 mult=1
XR396 n396 n397 vss sky130_fd_pr__res_high_po_1p41 L=3 mult=1
XR397 n397 n398 vss sky130_fd_pr__res_high_po_1p41 L=3 mult=1
XR398 n398 n399 vss sky130_fd_pr__res_high_po_1p41 L=3 mult=1
XR399 n399 n400 vss sky130_fd_pr__res_high_po_1p41 L=3 mult=1
XR400 n400 n401 vss sky130_fd_pr__res_high_po_1p41 L=3 mult=1
XR401 n401 n402 vss sky130_fd_pr__res_high_po_1p41 L=3 mult=1
XR402 n402 n403 vss sky130_fd_pr__res_high_po_1p41 L=3 mult=1
XR403 n403 n404 vss sky130_fd_pr__res_high_po_1p41 L=3 mult=1
XR404 n404 n405 vss sky130_fd_pr__res_high_po_1p41 L=3 mult=1
XR405 n405 n406 vss sky130_fd_pr__res_high_po_1p41 L=3 mult=1
XR406 n406 n407 vss sky130_fd_pr__res_high_po_1p41 L=3 mult=1
XR407 n407 n408 vss sky130_fd_pr__res_high_po_1p41 L=3 mult=1
XR408 n408 n409 vss sky130_fd_pr__res_high_po_1p41 L=3 mult=1
XR409 n409 n410 vss sky130_fd_pr__res_high_po_1p41 L=3 mult=1
XR410 n410 n411 vss sky130_fd_pr__res_high_po_1p41 L=3 mult=1
XR411 n411 n412 vss sky130_fd_pr__res_high_po_1p41 L=3 mult=1
XR412 n412 n413 vss sky130_fd_pr__res_high_po_1p41 L=3 mult=1
XR413 n413 n414 vss sky130_fd_pr__res_high_po_1p41 L=3 mult=1
XR414 n414 n415 vss sky130_fd_pr__res_high_po_1p41 L=3 mult=1
XR415 n415 n416 vss sky130_fd_pr__res_high_po_1p41 L=3 mult=1
XR416 n416 n417 vss sky130_fd_pr__res_high_po_1p41 L=3 mult=1
XR417 n417 n418 vss sky130_fd_pr__res_high_po_1p41 L=3 mult=1
XR418 n418 n419 vss sky130_fd_pr__res_high_po_1p41 L=3 mult=1
XR419 n419 n420 vss sky130_fd_pr__res_high_po_1p41 L=3 mult=1
XR420 n420 n421 vss sky130_fd_pr__res_high_po_1p41 L=3 mult=1
XR421 n421 n422 vss sky130_fd_pr__res_high_po_1p41 L=3 mult=1
XR422 n422 n423 vss sky130_fd_pr__res_high_po_1p41 L=3 mult=1
XR423 n423 n424 vss sky130_fd_pr__res_high_po_1p41 L=3 mult=1
XR424 n424 n425 vss sky130_fd_pr__res_high_po_1p41 L=3 mult=1
XR425 n425 n426 vss sky130_fd_pr__res_high_po_1p41 L=3 mult=1
XR426 n426 n427 vss sky130_fd_pr__res_high_po_1p41 L=3 mult=1
XR427 n427 n428 vss sky130_fd_pr__res_high_po_1p41 L=3 mult=1
XR428 n428 n429 vss sky130_fd_pr__res_high_po_1p41 L=3 mult=1
XR429 n429 n430 vss sky130_fd_pr__res_high_po_1p41 L=3 mult=1
XR430 n430 n431 vss sky130_fd_pr__res_high_po_1p41 L=3 mult=1
XR431 n431 n432 vss sky130_fd_pr__res_high_po_1p41 L=3 mult=1
XR432 n432 n433 vss sky130_fd_pr__res_high_po_1p41 L=3 mult=1
XR433 n433 n434 vss sky130_fd_pr__res_high_po_1p41 L=3 mult=1
XR434 n434 n435 vss sky130_fd_pr__res_high_po_1p41 L=3 mult=1
XR435 n435 n436 vss sky130_fd_pr__res_high_po_1p41 L=3 mult=1
XR436 n436 n437 vss sky130_fd_pr__res_high_po_1p41 L=3 mult=1
XR437 n437 n438 vss sky130_fd_pr__res_high_po_1p41 L=3 mult=1
XR438 n438 n439 vss sky130_fd_pr__res_high_po_1p41 L=3 mult=1
XR439 n439 n440 vss sky130_fd_pr__res_high_po_1p41 L=3 mult=1
XR440 n440 n441 vss sky130_fd_pr__res_high_po_1p41 L=3 mult=1
XR441 n441 n442 vss sky130_fd_pr__res_high_po_1p41 L=3 mult=1
XR442 n442 n443 vss sky130_fd_pr__res_high_po_1p41 L=3 mult=1
XR443 n443 n444 vss sky130_fd_pr__res_high_po_1p41 L=3 mult=1
XR444 n444 n445 vss sky130_fd_pr__res_high_po_1p41 L=3 mult=1
XR445 n445 n446 vss sky130_fd_pr__res_high_po_1p41 L=3 mult=1
XR446 n446 n447 vss sky130_fd_pr__res_high_po_1p41 L=3 mult=1
XR447 n447 n448 vss sky130_fd_pr__res_high_po_1p41 L=3 mult=1
XR448 n448 n449 vss sky130_fd_pr__res_high_po_1p41 L=3 mult=1
XR449 n449 n450 vss sky130_fd_pr__res_high_po_1p41 L=3 mult=1
XR450 n450 n451 vss sky130_fd_pr__res_high_po_1p41 L=3 mult=1
XR451 n451 n452 vss sky130_fd_pr__res_high_po_1p41 L=3 mult=1
XR452 n452 n453 vss sky130_fd_pr__res_high_po_1p41 L=3 mult=1
XR453 n453 n454 vss sky130_fd_pr__res_high_po_1p41 L=3 mult=1
XR454 n454 n455 vss sky130_fd_pr__res_high_po_1p41 L=3 mult=1
XR455 n455 n456 vss sky130_fd_pr__res_high_po_1p41 L=3 mult=1
XR456 n456 n457 vss sky130_fd_pr__res_high_po_1p41 L=3 mult=1
XR457 n457 n458 vss sky130_fd_pr__res_high_po_1p41 L=3 mult=1
XR458 n458 n459 vss sky130_fd_pr__res_high_po_1p41 L=3 mult=1
XR459 n459 n460 vss sky130_fd_pr__res_high_po_1p41 L=3 mult=1
XR460 n460 n461 vss sky130_fd_pr__res_high_po_1p41 L=3 mult=1
XR461 n461 n462 vss sky130_fd_pr__res_high_po_1p41 L=3 mult=1
XR462 n462 n463 vss sky130_fd_pr__res_high_po_1p41 L=3 mult=1
XR463 n463 n464 vss sky130_fd_pr__res_high_po_1p41 L=3 mult=1
XR464 n464 n465 vss sky130_fd_pr__res_high_po_1p41 L=3 mult=1
XR465 n465 n466 vss sky130_fd_pr__res_high_po_1p41 L=3 mult=1
XR466 n466 n467 vss sky130_fd_pr__res_high_po_1p41 L=3 mult=1
XR467 n467 n468 vss sky130_fd_pr__res_high_po_1p41 L=3 mult=1
XR468 n468 n469 vss sky130_fd_pr__res_high_po_1p41 L=3 mult=1
XR469 n469 n470 vss sky130_fd_pr__res_high_po_1p41 L=3 mult=1
XR470 n470 n471 vss sky130_fd_pr__res_high_po_1p41 L=3 mult=1
XR471 n471 n472 vss sky130_fd_pr__res_high_po_1p41 L=3 mult=1
XR472 n472 n473 vss sky130_fd_pr__res_high_po_1p41 L=3 mult=1
XR473 n473 n474 vss sky130_fd_pr__res_high_po_1p41 L=3 mult=1
XR474 n474 n475 vss sky130_fd_pr__res_high_po_1p41 L=3 mult=1
XR475 n475 n476 vss sky130_fd_pr__res_high_po_1p41 L=3 mult=1
XR476 n476 n477 vss sky130_fd_pr__res_high_po_1p41 L=3 mult=1
XR477 n477 n478 vss sky130_fd_pr__res_high_po_1p41 L=3 mult=1
XR478 n478 n479 vss sky130_fd_pr__res_high_po_1p41 L=3 mult=1
XR479 n479 n480 vss sky130_fd_pr__res_high_po_1p41 L=3 mult=1
XR480 n480 n481 vss sky130_fd_pr__res_high_po_1p41 L=3 mult=1
XR481 n481 n482 vss sky130_fd_pr__res_high_po_1p41 L=3 mult=1
XR482 n482 n483 vss sky130_fd_pr__res_high_po_1p41 L=3 mult=1
XR483 n483 n484 vss sky130_fd_pr__res_high_po_1p41 L=3 mult=1
XR484 n484 n485 vss sky130_fd_pr__res_high_po_1p41 L=3 mult=1
XR485 n485 n486 vss sky130_fd_pr__res_high_po_1p41 L=3 mult=1
XR486 n486 n487 vss sky130_fd_pr__res_high_po_1p41 L=3 mult=1
XR487 n487 n488 vss sky130_fd_pr__res_high_po_1p41 L=3 mult=1
XR488 n488 n489 vss sky130_fd_pr__res_high_po_1p41 L=3 mult=1
XR489 n489 n490 vss sky130_fd_pr__res_high_po_1p41 L=3 mult=1
XR490 n490 n491 vss sky130_fd_pr__res_high_po_1p41 L=3 mult=1
XR491 n491 n492 vss sky130_fd_pr__res_high_po_1p41 L=3 mult=1
XR492 n492 n493 vss sky130_fd_pr__res_high_po_1p41 L=3 mult=1
XR493 n493 n494 vss sky130_fd_pr__res_high_po_1p41 L=3 mult=1
XR494 n494 n495 vss sky130_fd_pr__res_high_po_1p41 L=3 mult=1
XR495 n495 n496 vss sky130_fd_pr__res_high_po_1p41 L=3 mult=1
XR496 n496 n497 vss sky130_fd_pr__res_high_po_1p41 L=3 mult=1
XR497 n497 n498 vss sky130_fd_pr__res_high_po_1p41 L=3 mult=1
XR498 n498 n499 vss sky130_fd_pr__res_high_po_1p41 L=3 mult=1
XR499 n499 n500 vss sky130_fd_pr__res_high_po_1p41 L=3 mult=1
XR500 n500 n501 vss sky130_fd_pr__res_high_po_1p41 L=3 mult=1
XR501 n501 n502 vss sky130_fd_pr__res_high_po_1p41 L=3 mult=1
XR502 n502 n503 vss sky130_fd_pr__res_high_po_1p41 L=3 mult=1
XR503 n503 n504 vss sky130_fd_pr__res_high_po_1p41 L=3 mult=1
XR504 n504 n505 vss sky130_fd_pr__res_high_po_1p41 L=3 mult=1
XR505 n505 n506 vss sky130_fd_pr__res_high_po_1p41 L=3 mult=1
XR506 n506 n507 vss sky130_fd_pr__res_high_po_1p41 L=3 mult=1
XR507 n507 n508 vss sky130_fd_pr__res_high_po_1p41 L=3 mult=1
XR508 n508 n509 vss sky130_fd_pr__res_high_po_1p41 L=3 mult=1
XR509 n509 n510 vss sky130_fd_pr__res_high_po_1p41 L=3 mult=1
XR510 n510 n511 vss sky130_fd_pr__res_high_po_1p41 L=3 mult=1
XR511 n511 n512 vss sky130_fd_pr__res_high_po_1p41 L=3 mult=1
XR512 n512 n513 vss sky130_fd_pr__res_high_po_1p41 L=3 mult=1
XR513 n513 n514 vss sky130_fd_pr__res_high_po_1p41 L=3 mult=1
XR514 n514 n515 vss sky130_fd_pr__res_high_po_1p41 L=3 mult=1
XR515 n515 n516 vss sky130_fd_pr__res_high_po_1p41 L=3 mult=1
XR516 n516 n517 vss sky130_fd_pr__res_high_po_1p41 L=3 mult=1
XR517 n517 n518 vss sky130_fd_pr__res_high_po_1p41 L=3 mult=1
XR518 n518 n519 vss sky130_fd_pr__res_high_po_1p41 L=3 mult=1
XR519 n519 top vss sky130_fd_pr__res_high_po_1p41 L=3 mult=1
.ends
