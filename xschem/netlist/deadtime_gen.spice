** sch_path: /foss/projects/synchronous-buck-converter-/xschem/deadtime_gen.sch
.subckt deadtime_gen pwm ls_en hs_on_s ls_on_s hs_on ls_on hl0 hl1 hl2 hl3 hl4 hl5 hl6 hl7 lh0 lh1 lh2 lh3 lh4 lh5 lh6 lh7 vdd vin
+ vss
*.PININFO pwm:B ls_en:B hs_on_s:B ls_on_s:B hs_on:B ls_on:B hl0:B hl1:B hl2:B hl3:B hl4:B hl5:B hl6:B hl7:B lh0:B lh1:B lh2:B
*+ lh3:B lh4:B lh5:B lh6:B lh7:B vdd:B vin:B vss:B
XSH hs_on_s vdd vss vss vin vin hs_on_lv sky130_fd_sc_hvl__lsbufhv2lv_1
XSL ls_on_s vdd vss vss vin vin ls_on_lv sky130_fd_sc_hvl__lsbufhv2lv_1
XIH hs_on_lv vss vss vdd vdd hs_off_ok sky130_fd_sc_hd__inv_1
XIL ls_on_lv vss vss vdd vdd ls_off_ok sky130_fd_sc_hd__inv_1
XDH hs_off_ok hl_ok hl0 hl1 hl2 hl3 hl4 hl5 hl6 hl7 vdd vss dt_prog
XDL ls_off_ok lh_ok lh0 lh1 lh2 lh3 lh4 lh5 lh6 lh7 vdd vss dt_prog
XIP pwm vss vss vdd vdd pwm_n sky130_fd_sc_hd__inv_1
XAH pwm lh_ok vss vss vdd vdd hs_on sky130_fd_sc_hd__and2_1
XAL pwm_n ls_en hl_ok vss vss vdd vdd ls_on sky130_fd_sc_hd__and3_1
.ends

* expanding   symbol:  dt_prog.sym # of pins=12
** sym_path: /foss/projects/synchronous-buck-converter-/xschem/dt_prog.sym
** sch_path: /foss/projects/synchronous-buck-converter-/xschem/dt_prog.sch
.subckt dt_prog in out t0 t1 t2 t3 t4 t5 t6 t7 vdd vss
*.PININFO in:B out:B t0:B t1:B t2:B t3:B t4:B t5:B t6:B t7:B vdd:B vss:B
X0 in x1 t0 vdd vss dt_stage
X1 x1 x2 t1 vdd vss dt_stage
X2 x2 x3 t2 vdd vss dt_stage
X3 x3 x4 t3 vdd vss dt_stage
X4 x4 x5 t4 vdd vss dt_stage
X5 x5 x6 t5 vdd vss dt_stage
X6 x6 x7 t6 vdd vss dt_stage
X7 x7 out t7 vdd vss dt_stage
.ends

* expanding   symbol:  dt_stage.sym # of pins=5
** sym_path: /foss/projects/synchronous-buck-converter-/xschem/dt_stage.sym
** sch_path: /foss/projects/synchronous-buck-converter-/xschem/dt_stage.sch
.subckt dt_stage in out sel vdd vss
*.PININFO in:B out:B sel:B vdd:B vss:B
XT in d vdd vss dt_tap
XM in d sel vss vss vdd vdd out sky130_fd_sc_hd__mux2_1
.ends

* expanding   symbol:  dt_tap.sym # of pins=4
** sym_path: /foss/projects/synchronous-buck-converter-/xschem/dt_tap.sym
** sch_path: /foss/projects/synchronous-buck-converter-/xschem/dt_tap.sch
.subckt dt_tap in out vdd vss
*.PININFO in:B out:B vdd:B vss:B
X1 in vss vss vdd vdd a1 sky130_fd_sc_hd__dlygate4sd3_1
X2 a1 vss vss vdd vdd a2 sky130_fd_sc_hd__dlygate4sd3_1
X3 a2 vss vss vdd vdd a3 sky130_fd_sc_hd__dlygate4sd3_1
X4 a3 vss vss vdd vdd a4 sky130_fd_sc_hd__dlygate4sd3_1
X5 a4 vss vss vdd vdd out sky130_fd_sc_hd__dlygate4sd3_1
.ends
